| IBIS file stm32g431_441_wlcsp49.ibs
[IBIS ver]   4.2
[File name]  stm32g431_441_wlcsp49.ibs
[File Rev]   1.0
[Date]   05-07-2019
[Source]   Data Created at STMicroelectronics
[Notes]   File originated from ELDO simulations.
[Disclaimer] This information is for modeling purpose only and is
   not guaranted. The information is subject to change without
   notice.
[Copyright]  Copyright 2019 STMicroelectronics Inc.
|   Component stm32g431_441_wlcsp49
[Component] stm32g431_441_wlcsp49
[Manufacturer] STMicroelectronics
[Package]
| variable   typ   min   max
R_pkg  1.08E-01  7.99E-03  3.21E-01
L_pkg  2.47E-10  6.70E-11  6.25E-10
C_pkg  7.61E-13  6.81E-13  9.07E-13
[Pin]   signal_name   model_name
A1  PA15  io8prog2m25m50m120m_sudq_i2c_ft
A2  PC11  io8prog2m25m50m120m_sudq_i2c_ft
A3  PB3  io8prog2m25m50m120m_sudq_ft
A4  PB5  io8prog2m25m50m120m_sudq_i2c_ft
A5  PB7  io8prog2m25m50m120m_sudq_i2c_ft
A6  VSS  gnd
A7  VDD  power
B1  PA12  io8usblsfs_otg2
B2  PA13  io8prog2m25m50m120m_sudq_i2c_ft
B3  PA14  io8prog2m25m50m120m_sudq_i2c_ft
B4  PB4  io6usb_bmc_pd_cc_ft
B5  PB8  io8prog2m25m50m120m_sudq_i2c_ft
B6  PB9  io8prog2m25m50m120m_sudq_i2c_ft
B7  VBAT  power
C1  PA11  io8usblsfs_otg2
C2  PA10  io8prog2m25m50m120m_sudq_ft
C3  PA9  io8prog2m25m50m120m_sudq_ft
C4  PB6  io6usb_bmc_pd_cc_ft
C5  PC13  io8prog2m25m50m120m_sudq_ft
C6  PG10  ioreset_ft_v33
C7  PC14  io8prog2m25m50m120m_sudq_ft
D1  PC6  io8prog2m25m50m120m_sudq_i2c_ft
D2  PA8  io8prog2m25m50m120m_sudq_i2c_ft
D3  PB14  io8prog2m25m50m120m_sudq_ft
D4  PC4  io8prog2m25m50m120m_sudq_i2c_ft
D5  PA7  io8prog2m25m50m120m_sudq_ft
D6  PA1  io8prog2m25m50m120m_sudq_ft
D7  PC15  io8prog2m25m50m120m_sudq_ft
E1  PB15  io8prog2m25m50m120m_sudq_ft
E2  PB13  io8prog2m25m50m120m_sudq_ft
E3  PB11  io8prog2m25m50m120m_sudq_ft
E4  PB1  io8prog2m25m50m120m_sudq_ft
E5  PA4  io8prog2m25m50m120m_sudq_ft
E6  PF1  io8prog2m25m50m120m_sudq_ft
E7  PF0  io8prog2m25m50m120m_sudq_i2c_ft
F1  PB12  io8prog2m25m50m120m_sudq_ft
F2  PB10  io8prog2m25m50m120m_sudq_ft
F3  VREFP  nc
F4  PB2  io8prog2m25m50m120m_sudq_ft
F5  PA5  io8prog2m25m50m120m_sudq_ft
F6  PA2  io8prog2m25m50m120m_sudq_ft
F7  PA0  io8prog2m25m50m120m_sudq_ft
G1  VDD  power
G2  VSS  gnd
G3  VDDA  nc
G4  VSSA  nc
G5  PB0  io8prog2m25m50m120m_sudq_ft
G6  PA6  io8prog2m25m50m120m_sudq_ft
G7  PA3  io8prog2m25m50m120m_sudq_ft
[Package Model]   stm32g431_441_wlcsp_49
[Pin Mapping]   pulldown_ref   pullup_ref   | Comment
A1  gndio  vddio
A2  gndio  vddio
A3  gndio  vddio
A4  gndio  vddio
A5  gndio  vddio
A6  gndio  nc
A7  nc  vddio
B1  gndio  vddio
B2  gndio  vddio
B3  gndio  vddio
B4  gndio  vddio
B5  gndio  vddio
B6  gndio  vddio
B7  nc  vswitch
C1  gndio  vddio
C2  gndio  vddio
C3  gndio  vddio
C4  gndio  vddio
C5  gndio  vddio  | Depending on IO usage
| C5  gndio  vswitch  | Depending on IO usage
C6  gndio  vddio
C7  gndio  vddio  | Depending on IO usage
| C7  gndio  vswitch  | Depending on IO usage
D1  gndio  vddio
D2  gndio  vddio
D3  gndio  vddio
D4  gndio  vddio
D5  gndio  vddio
D6  gndio  vddio
D7  gndio  vddio  | Depending on IO usage
| D7  gndio  vswitch  | Depending on IO usage
E1  gndio  vddio
E2  gndio  vddio
E3  gndio  vddio
E4  gndio  vddio
E5  gndio  vddio
E6  gndio  vddio
E7  gndio  vddio
F1  gndio  vddio
F2  gndio  vddio
F3  nc  nc
F4  gndio  vddio
F5  gndio  vddio
F6  gndio  vddio
F7  gndio  vddio
G1  nc  vddio
G2  gndio  nc
G3  nc  nc
G4  nc  nc
G5  gndio  vddio
G6  gndio  vddio
G7  gndio  vddio
[Model Selector] io6usb_bmc_pd_cc_ft
usb_bmc_emit_pdccpd  "BMC PD emitter  + PD"
usb_bmc_emit_pdcc3a0  "BMC PD emitter  + 3rd PU"
usb_bmc_emit_pdcc1a5  "BMC PD emitter  + 2nd PU"
usb_bmc_emit_pdccusb  "BMC PD emitter  + 1st PU"
usb_bmc_emit  "BMC PD emitter "
io2_pdcc_ft_3v3_lowspeed  "GPIO-3.3V range - low speed"
io2_pdcc_ft_3v3_mediumspeed  "GPIO-3.3V range - medium speed"
io2_pdcc_ft_3v3_lowspeed_pu  "GPIO-3.3V range - low speed - pull up"
io2_pdcc_ft_3v3_mediumspeed_pu  "GPIO-3.3V range - medium speed - pull up"
io2_pdcc_ft_3v3_lowspeed_pd  "GPIO-3.3V range - low speed - pull down"
io2_pdcc_ft_3v3_mediumspeed_pd  "GPIO-3.3V range - medium speed - pull down"
io2_pdcc_ft_1v8_lowspeed  "GPIO-1.8V range - low speed"
io2_pdcc_ft_1v8_mediumspeed  "GPIO-1.8V range - medium speed"
io2_pdcc_ft_1v8_lowspeed_pu  "GPIO-1.8V range - low speed - pull up"
io2_pdcc_ft_1v8_mediumspeed_pu  "GPIO-1.8V range - medium speed - pull up"
io2_pdcc_ft_1v8_lowspeed_pd  "GPIO-1.8V range - low speed - pull down"
io2_pdcc_ft_1v8_mediumspeed_pd  "GPIO-1.8V range - medium speed - pull down"
io2_pdcc_ft_1v2_lowspeed  "GPIO-1.2V range - low speed"
io2_pdcc_ft_1v2_mediumspeed  "GPIO-1.2V range - medium speed"
io2_pdcc_ft_1v2_lowspeed_pu  "GPIO-1.2V range - low speed - pull up"
io2_pdcc_ft_1v2_mediumspeed_pu  "GPIO-1.2V range - medium speed - pull up"
io2_pdcc_ft_1v2_lowspeed_pd  "GPIO-1.2V range - low speed - pull down"
io2_pdcc_ft_1v2_mediumspeed_pd  "GPIO-1.2V range - medium speed - pull down"
[Model Selector] io8prog2m25m50m120m_sudq_ft
iols8p_sudq_ft_pd_lv  "IO low speed, PD=40kOhm - 1P8V"
iols8p_sudq_ft_pu_lv  "IO low speed, PU=40kOhm - 1P8V"
iols8p_sudq_ft_lv  "IO low speed - 1P8V"
iols8p_sudq_ft_pd  "IO low speed, PD=40kOhm - 3P3V"
iols8p_sudq_ft_pu  "IO low speed, PU=40kOhm - 3P3V"
iols8p_sudq_ft  "IO low speed - 3P3V"
iofs8p_sudq_ft_pd_lv  "IO full speed, PD=40kOhm - 1P8V"
iofs8p_sudq_ft_pu_lv  "IO full speed, PU=40kOhm - 1P8V"
iofs8p_sudq_ft_lv  "IO full speed - 1P8V"
iofs8p_sudq_ft_pd  "IO full speed, PD=40kOhm - 3P3V"
iofs8p_sudq_ft_pu  "IO full speed, PU=40kOhm - 3P3V"
iofs8p_sudq_ft  "IO full speed - 3P3V"
ioms8p_sudq_ft_pd_lv  "IO medium speed, PD=40kOhm - 1P8V"
ioms8p_sudq_ft_pu_lv  "IO medium speed, PU=40kOhm - 1P8V"
ioms8p_sudq_ft_lv  "IO medium speed - 1P8V"
ioms8p_sudq_ft_pd  "IO medium speed, PD=40kOhm - 3P3V"
ioms8p_sudq_ft_pu  "IO medium speed, PU=40kOhm - 3P3V"
ioms8p_sudq_ft  "IO medium speed - 3P3V"
iohs8p_sudq_ft_pd_lv  "IO high speed, PD=40kOhm - 1P8V"
iohs8p_sudq_ft_pu_lv  "IO high speed, PU=40kOhm - 1P8V"
iohs8p_sudq_ft_lv  "IO high speed - 1P8V"
iohs8p_sudq_ft_pd  "IO high speed, PD=40kOhm - 3P3V"
iohs8p_sudq_ft_pu  "IO high speed, PU=40kOhm - 3P3V"
iohs8p_sudq_ft  "IO high speed - 3P3V"
[Model Selector] io8prog2m25m50m120m_sudq_i2c_ft
io8prog_1v8_i2c_pd  "5V Tol GPIO 1.8V range i2c functionality with pull down"
io8prog_1v8_i2c_pu  "5V Tol GPIO 1.8V range i2c functionality with pull up"
io8prog_1v8_i2c  "5V Tol GPIO 1.8V range i2c functionality"
io8prog_3v3_i2c_pd  "5V Tol GPIO 3.3V range i2c functionality with pull down"
io8prog_3v3_i2c_pu  "5V Tol GPIO 3.3V range i2c functionality with pull up"
io8prog_3v3_i2c  "5V Tol GPIO 3.3V range i2c functionality"
iols8p_sudq_ft_pd_lv  "IO low speed, PD=40kOhm - 1P8V"
iols8p_sudq_ft_pu_lv  "IO low speed, PU=40kOhm - 1P8V"
iols8p_sudq_ft_lv  "IO low speed - 1P8V"
iols8p_sudq_ft_pd  "IO low speed, PD=40kOhm - 3P3V"
iols8p_sudq_ft_pu  "IO low speed, PU=40kOhm - 3P3V"
iols8p_sudq_ft  "IO low speed - 3P3V"
iofs8p_sudq_ft_pd_lv  "IO full speed, PD=40kOhm - 1P8V"
iofs8p_sudq_ft_pu_lv  "IO full speed, PU=40kOhm - 1P8V"
iofs8p_sudq_ft_lv  "IO full speed - 1P8V"
iofs8p_sudq_ft_pd  "IO full speed, PD=40kOhm - 3P3V"
iofs8p_sudq_ft_pu  "IO full speed, PU=40kOhm - 3P3V"
iofs8p_sudq_ft  "IO full speed - 3P3V"
ioms8p_sudq_ft_pd_lv  "IO medium speed, PD=40kOhm - 1P8V"
ioms8p_sudq_ft_pu_lv  "IO medium speed, PU=40kOhm - 1P8V"
ioms8p_sudq_ft_lv  "IO medium speed - 1P8V"
ioms8p_sudq_ft_pd  "IO medium speed, PD=40kOhm - 3P3V"
ioms8p_sudq_ft_pu  "IO medium speed, PU=40kOhm - 3P3V"
ioms8p_sudq_ft  "IO medium speed - 3P3V"
iohs8p_sudq_ft_pd_lv  "IO high speed, PD=40kOhm - 1P8V"
iohs8p_sudq_ft_pu_lv  "IO high speed, PU=40kOhm - 1P8V"
iohs8p_sudq_ft_lv  "IO high speed - 1P8V"
iohs8p_sudq_ft_pd  "IO high speed, PD=40kOhm - 3P3V"
iohs8p_sudq_ft_pu  "IO high speed, PU=40kOhm - 3P3V"
iohs8p_sudq_ft  "IO high speed - 3P3V"
[Model Selector] io8usblsfs_otg2
usb_ls_pd  "USB Low Speed mode - Pull Down"
usb_ls_pu2  "USB Low Speed mode - Pull up 2"
usb_ls_pu  "USB Low Speed mode - Pull up"
usb_fs  "USB Low Speed mode"
usb_fs_pd  "USB Full Speed mode - Pull Down"
usb_fs_pu2  "USB Full Speed mode - Pull up 2"
usb_fs_pu  "USB Full Speed mode - Pull up"
[Model Selector] ioreset_ft_v33
ioreset_1v2_pu  "RESET 1.2V range with PU"
ioreset_1v2  "RESET 1.2V range"
ioreset_1v8_pu  "RESET 1.8V range with PU"
ioreset_1v8  "RESET 1.8V range"
ioreset_3v3_pu  "RESET 3.3V range with PU"
ioreset_3v3  "RESET 3.3V range"
[Define Package Model]  stm32g431_441_wlcsp_49
[Manufacturer]  Unknown
[OEM]  Unknown
[Description]  None
[Number Of Pins]  47
[Pin Numbers]
| Pin Num   Terminal Name
F7 | PA0
D6 | PA1
F6 | PA2
G7 | PA3
E5 | PA4
F5 | PA5
G6 | PA6
D5 | PA7
D2 | PA8
C3 | PA9
C2 | PA10
C1 | PA11
B1 | PA12
B2 | PA13
B3 | PA14
A1 | PA15
G5 | PB0
E4 | PB1
F4 | PB2
A3 | PB3
B4 | PB4
A4 | PB5
C4 | PB6
A5 | PB7
B5 | PB8
B6 | PB9
F2 | PB10
E3 | PB11
F1 | PB12
E2 | PB13
D3 | PB14
E1 | PB15
D4 | PC4
D1 | PC6
A2 | PC11
C5 | PC13
C7 | PC14
D7 | PC15
E7 | PF0
E6 | PF1
C6 | PG10
B7 | VBAT
A7 | VDD
G3 | VDDA
F3 | VREFP
A6 | VSS
G4 | VSSA
[Model Data]
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[End Model Data]
[End Package Model]
| Models and submodels in the file (66): usb_bmc_emit_pdccpd (I/O), usb_bmc_emit_pdcc3a0 (I/O), usb_bmc_emit_pdcc1a5 (I/O), usb_bmc_emit_pdccusb (I/O), usb_bmc_emit (I/O), io2_pdcc_ft_3v3_lowspeed (I/O), io2_pdcc_ft_3v3_mediumspeed (I/O), io2_pdcc_ft_3v3_lowspeed_pu (I/O), io2_pdcc_ft_3v3_mediumspeed_pu (I/O), io2_pdcc_ft_3v3_lowspeed_pd (I/O), io2_pdcc_ft_3v3_mediumspeed_pd (I/O), io2_pdcc_ft_1v8_lowspeed (I/O), io2_pdcc_ft_1v8_mediumspeed (I/O), io2_pdcc_ft_1v8_lowspeed_pu (I/O), io2_pdcc_ft_1v8_mediumspeed_pu (I/O), io2_pdcc_ft_1v8_lowspeed_pd (I/O), io2_pdcc_ft_1v8_mediumspeed_pd (I/O), io2_pdcc_ft_1v2_lowspeed (I/O), io2_pdcc_ft_1v2_mediumspeed (I/O), io2_pdcc_ft_1v2_lowspeed_pu (I/O), io2_pdcc_ft_1v2_mediumspeed_pu (I/O), io2_pdcc_ft_1v2_lowspeed_pd (I/O), io2_pdcc_ft_1v2_mediumspeed_pd (I/O), iols8p_sudq_ft_pd_lv (I/O), iols8p_sudq_ft_pu_lv (I/O), iols8p_sudq_ft_lv (I/O), iols8p_sudq_ft_pd (I/O), iols8p_sudq_ft_pu (I/O), iols8p_sudq_ft (I/O), iofs8p_sudq_ft_pd_lv (I/O), iofs8p_sudq_ft_pu_lv (I/O), iofs8p_sudq_ft_lv (I/O), iofs8p_sudq_ft_pd (I/O), iofs8p_sudq_ft_pu (I/O), iofs8p_sudq_ft (I/O), ioms8p_sudq_ft_pd_lv (I/O), ioms8p_sudq_ft_pu_lv (I/O), ioms8p_sudq_ft_lv (I/O), ioms8p_sudq_ft_pd (I/O), ioms8p_sudq_ft_pu (I/O), ioms8p_sudq_ft (I/O), iohs8p_sudq_ft_pd_lv (I/O), iohs8p_sudq_ft_pu_lv (I/O), iohs8p_sudq_ft_lv (I/O), iohs8p_sudq_ft_pd (I/O), iohs8p_sudq_ft_pu (I/O), iohs8p_sudq_ft (I/O), io8prog_1v8_i2c_pd (I/O), io8prog_1v8_i2c_pu (I/O), io8prog_1v8_i2c (I/O), io8prog_3v3_i2c_pd (I/O), io8prog_3v3_i2c_pu (I/O), io8prog_3v3_i2c (I/O), usb_ls_pd (I/O), usb_ls_pu2 (I/O), usb_ls_pu (I/O), usb_fs (I/O), usb_fs_pd (I/O), usb_fs_pu2 (I/O), usb_fs_pu (I/O), ioreset_1v2_pu (I/O_open_drain), ioreset_1v2 (I/O_open_drain), ioreset_1v8_pu (I/O_open_drain), ioreset_1v8 (I/O_open_drain), ioreset_3v3_pu (I/O_open_drain), ioreset_3v3 (I/O_open_drain)
