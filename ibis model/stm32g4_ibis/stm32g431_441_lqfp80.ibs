| IBIS file stm32g431_441_lqfp80.ibs
[IBIS ver]   4.2
[File name]  stm32g431_441_lqfp80.ibs
[File Rev]   1.0
[Date]   05-07-2019
[Source]   Data Created at STMicroelectronics
[Notes]   File originated from ELDO simulations.
[Disclaimer] This information is for modeling purpose only and is
   not guaranted. The information is subject to change without
   notice.
[Copyright]  Copyright 2019 STMicroelectronics Inc.
|   Component stm32g431_441_lqfp80
[Component] stm32g431_441_lqfp80
[Manufacturer] STMicroelectronics
[Package]
| variable   typ   min   max
R_pkg  4.05E-01  3.58E-01  5.04E-01
L_pkg  4.40E-09  3.62E-09  5.40E-09
C_pkg  7.79E-13  7.04E-13  8.83E-13
[Pin]   signal_name   model_name
1  VBAT  power
2  PC13  io8prog2m25m50m120m_sudq_ft
3  PC14  io8prog2m25m50m120m_sudq_ft
4  PC15  io8prog2m25m50m120m_sudq_ft
5  PF0  io8prog2m25m50m120m_sudq_i2c_ft
6  PF1  io8prog2m25m50m120m_sudq_ft
7  PG10  ioreset_ft_v33
8  PC0  io8prog2m25m50m120m_sudq_ft
9  PC1  io8prog2m25m50m120m_sudq_ft
10  PC2  io8prog2m25m50m120m_sudq_ft
11  PC3  io8prog2m25m50m120m_sudq_ft
12  PA0  io8prog2m25m50m120m_sudq_ft
13  PA1  io8prog2m25m50m120m_sudq_ft
14  PA2  io8prog2m25m50m120m_sudq_ft
15  VSS  gnd
16  VDD  power
17  PA3  io8prog2m25m50m120m_sudq_ft
18  PA4  io8prog2m25m50m120m_sudq_ft
19  PA5  io8prog2m25m50m120m_sudq_ft
20  PA6  io8prog2m25m50m120m_sudq_ft
21  PA7  io8prog2m25m50m120m_sudq_ft
22  PC4  io8prog2m25m50m120m_sudq_i2c_ft
23  PC5  io8prog2m25m50m120m_sudq_ft
24  PB0  io8prog2m25m50m120m_sudq_ft
25  PB1  io8prog2m25m50m120m_sudq_ft
26  PB2  io8prog2m25m50m120m_sudq_ft
27  VSSA  nc
28  VREFP  nc
29  VDDA  nc
30  PE7  io8prog2m25m50m120m_sudq_ft
31  PE8  io8prog2m25m50m120m_sudq_ft
32  PE9  io8prog2m25m50m120m_sudq_ft
33  PE10  io8prog2m25m50m120m_sudq_ft
34  PE11  io8prog2m25m50m120m_sudq_ft
35  PE12  io8prog2m25m50m120m_sudq_ft
36  PE13  io8prog2m25m50m120m_sudq_ft
37  PE14  io8prog2m25m50m120m_sudq_ft
38  PE15  io8prog2m25m50m120m_sudq_ft
39  PB10  io8prog2m25m50m120m_sudq_ft
40  VSS  gnd
41  VDD  power
42  PB11  io8prog2m25m50m120m_sudq_ft
43  PB12  io8prog2m25m50m120m_sudq_ft
44  PB13  io8prog2m25m50m120m_sudq_ft
45  PB14  io8prog2m25m50m120m_sudq_ft
46  PB15  io8prog2m25m50m120m_sudq_ft
47  PD8  io8prog2m25m50m120m_sudq_ft
48  PD9  io8prog2m25m50m120m_sudq_ft
49  PD10  io8prog2m25m50m120m_sudq_ft
50  VSS  gnd
51  VDD  power
52  PC6  io8prog2m25m50m120m_sudq_i2c_ft
53  PC7  io8prog2m25m50m120m_sudq_i2c_ft
54  PC8  io8prog2m25m50m120m_sudq_i2c_ft
55  PC9  io8prog2m25m50m120m_sudq_i2c_ft
56  PA8  io8prog2m25m50m120m_sudq_i2c_ft
57  PA9  io8prog2m25m50m120m_sudq_ft
58  PA10  io8prog2m25m50m120m_sudq_ft
59  PA11  io8usblsfs_otg2
60  PA12  io8usblsfs_otg2
61  VSS  gnd
62  VDD  power
63  PA13  io8prog2m25m50m120m_sudq_i2c_ft
64  PA14  io8prog2m25m50m120m_sudq_i2c_ft
65  PA15  io8prog2m25m50m120m_sudq_i2c_ft
66  PC10  io8prog2m25m50m120m_sudq_ft
67  PC11  io8prog2m25m50m120m_sudq_i2c_ft
68  PC12  io8prog2m25m50m120m_sudq_ft
69  PD0  io8prog2m25m50m120m_sudq_ft
70  PD1  io8prog2m25m50m120m_sudq_ft
71  PD2  io8prog2m25m50m120m_sudq_ft
72  PB3  io8prog2m25m50m120m_sudq_ft
73  PB4  io6usb_bmc_pd_cc_ft
74  PB5  io8prog2m25m50m120m_sudq_i2c_ft
75  PB6  io6usb_bmc_pd_cc_ft
76  PB7  io8prog2m25m50m120m_sudq_i2c_ft
77  PB8  io8prog2m25m50m120m_sudq_i2c_ft
78  PB9  io8prog2m25m50m120m_sudq_i2c_ft
79  VSS  gnd
80  VDD  power
[Package Model]   stm32g431_441_lqfp_80
[Pin Mapping]   pulldown_ref   pullup_ref   | Comment
1  nc  vswitch
2  gndio  vddio  | Depending on IO usage
| 2  gndio  vswitch  | Depending on IO usage
3  gndio  vddio  | Depending on IO usage
| 3  gndio  vswitch  | Depending on IO usage
4  gndio  vddio  | Depending on IO usage
| 4  gndio  vswitch  | Depending on IO usage
5  gndio  vddio
6  gndio  vddio
7  gndio  vddio
8  gndio  vddio
9  gndio  vddio
10  gndio  vddio
11  gndio  vddio
12  gndio  vddio
13  gndio  vddio
14  gndio  vddio
15  gndio  nc
16  nc  vddio
17  gndio  vddio
18  gndio  vddio
19  gndio  vddio
20  gndio  vddio
21  gndio  vddio
22  gndio  vddio
23  gndio  vddio
24  gndio  vddio
25  gndio  vddio
26  gndio  vddio
27  nc  nc
28  nc  nc
29  nc  nc
30  gndio  vddio
31  gndio  vddio
32  gndio  vddio
33  gndio  vddio
34  gndio  vddio
35  gndio  vddio
36  gndio  vddio
37  gndio  vddio
38  gndio  vddio
39  gndio  vddio
40  gndio  nc
41  nc  vddio
42  gndio  vddio
43  gndio  vddio
44  gndio  vddio
45  gndio  vddio
46  gndio  vddio
47  gndio  vddio
48  gndio  vddio
49  gndio  vddio
50  gndio  nc
51  nc  vddio
52  gndio  vddio
53  gndio  vddio
54  gndio  vddio
55  gndio  vddio
56  gndio  vddio
57  gndio  vddio
58  gndio  vddio
59  gndio  vddio
60  gndio  vddio
61  gndio  nc
62  nc  vddio
63  gndio  vddio
64  gndio  vddio
65  gndio  vddio
66  gndio  vddio
67  gndio  vddio
68  gndio  vddio
69  gndio  vddio
70  gndio  vddio
71  gndio  vddio
72  gndio  vddio
73  gndio  vddio
74  gndio  vddio
75  gndio  vddio
76  gndio  vddio
77  gndio  vddio
78  gndio  vddio
79  gndio  nc
80  nc  vddio
[Model Selector] io6usb_bmc_pd_cc_ft
usb_bmc_emit_pdccpd  "BMC PD emitter  + PD"
usb_bmc_emit_pdcc3a0  "BMC PD emitter  + 3rd PU"
usb_bmc_emit_pdcc1a5  "BMC PD emitter  + 2nd PU"
usb_bmc_emit_pdccusb  "BMC PD emitter  + 1st PU"
usb_bmc_emit  "BMC PD emitter "
io2_pdcc_ft_3v3_lowspeed  "GPIO-3.3V range - low speed"
io2_pdcc_ft_3v3_mediumspeed  "GPIO-3.3V range - medium speed"
io2_pdcc_ft_3v3_lowspeed_pu  "GPIO-3.3V range - low speed - pull up"
io2_pdcc_ft_3v3_mediumspeed_pu  "GPIO-3.3V range - medium speed - pull up"
io2_pdcc_ft_3v3_lowspeed_pd  "GPIO-3.3V range - low speed - pull down"
io2_pdcc_ft_3v3_mediumspeed_pd  "GPIO-3.3V range - medium speed - pull down"
io2_pdcc_ft_1v8_lowspeed  "GPIO-1.8V range - low speed"
io2_pdcc_ft_1v8_mediumspeed  "GPIO-1.8V range - medium speed"
io2_pdcc_ft_1v8_lowspeed_pu  "GPIO-1.8V range - low speed - pull up"
io2_pdcc_ft_1v8_mediumspeed_pu  "GPIO-1.8V range - medium speed - pull up"
io2_pdcc_ft_1v8_lowspeed_pd  "GPIO-1.8V range - low speed - pull down"
io2_pdcc_ft_1v8_mediumspeed_pd  "GPIO-1.8V range - medium speed - pull down"
io2_pdcc_ft_1v2_lowspeed  "GPIO-1.2V range - low speed"
io2_pdcc_ft_1v2_mediumspeed  "GPIO-1.2V range - medium speed"
io2_pdcc_ft_1v2_lowspeed_pu  "GPIO-1.2V range - low speed - pull up"
io2_pdcc_ft_1v2_mediumspeed_pu  "GPIO-1.2V range - medium speed - pull up"
io2_pdcc_ft_1v2_lowspeed_pd  "GPIO-1.2V range - low speed - pull down"
io2_pdcc_ft_1v2_mediumspeed_pd  "GPIO-1.2V range - medium speed - pull down"
[Model Selector] io8prog2m25m50m120m_sudq_ft
iols8p_sudq_ft_pd_lv  "IO low speed, PD=40kOhm - 1P8V"
iols8p_sudq_ft_pu_lv  "IO low speed, PU=40kOhm - 1P8V"
iols8p_sudq_ft_lv  "IO low speed - 1P8V"
iols8p_sudq_ft_pd  "IO low speed, PD=40kOhm - 3P3V"
iols8p_sudq_ft_pu  "IO low speed, PU=40kOhm - 3P3V"
iols8p_sudq_ft  "IO low speed - 3P3V"
iofs8p_sudq_ft_pd_lv  "IO full speed, PD=40kOhm - 1P8V"
iofs8p_sudq_ft_pu_lv  "IO full speed, PU=40kOhm - 1P8V"
iofs8p_sudq_ft_lv  "IO full speed - 1P8V"
iofs8p_sudq_ft_pd  "IO full speed, PD=40kOhm - 3P3V"
iofs8p_sudq_ft_pu  "IO full speed, PU=40kOhm - 3P3V"
iofs8p_sudq_ft  "IO full speed - 3P3V"
ioms8p_sudq_ft_pd_lv  "IO medium speed, PD=40kOhm - 1P8V"
ioms8p_sudq_ft_pu_lv  "IO medium speed, PU=40kOhm - 1P8V"
ioms8p_sudq_ft_lv  "IO medium speed - 1P8V"
ioms8p_sudq_ft_pd  "IO medium speed, PD=40kOhm - 3P3V"
ioms8p_sudq_ft_pu  "IO medium speed, PU=40kOhm - 3P3V"
ioms8p_sudq_ft  "IO medium speed - 3P3V"
iohs8p_sudq_ft_pd_lv  "IO high speed, PD=40kOhm - 1P8V"
iohs8p_sudq_ft_pu_lv  "IO high speed, PU=40kOhm - 1P8V"
iohs8p_sudq_ft_lv  "IO high speed - 1P8V"
iohs8p_sudq_ft_pd  "IO high speed, PD=40kOhm - 3P3V"
iohs8p_sudq_ft_pu  "IO high speed, PU=40kOhm - 3P3V"
iohs8p_sudq_ft  "IO high speed - 3P3V"
[Model Selector] io8prog2m25m50m120m_sudq_i2c_ft
io8prog_1v8_i2c_pd  "5V Tol GPIO 1.8V range i2c functionality with pull down"
io8prog_1v8_i2c_pu  "5V Tol GPIO 1.8V range i2c functionality with pull up"
io8prog_1v8_i2c  "5V Tol GPIO 1.8V range i2c functionality"
io8prog_3v3_i2c_pd  "5V Tol GPIO 3.3V range i2c functionality with pull down"
io8prog_3v3_i2c_pu  "5V Tol GPIO 3.3V range i2c functionality with pull up"
io8prog_3v3_i2c  "5V Tol GPIO 3.3V range i2c functionality"
iols8p_sudq_ft_pd_lv  "IO low speed, PD=40kOhm - 1P8V"
iols8p_sudq_ft_pu_lv  "IO low speed, PU=40kOhm - 1P8V"
iols8p_sudq_ft_lv  "IO low speed - 1P8V"
iols8p_sudq_ft_pd  "IO low speed, PD=40kOhm - 3P3V"
iols8p_sudq_ft_pu  "IO low speed, PU=40kOhm - 3P3V"
iols8p_sudq_ft  "IO low speed - 3P3V"
iofs8p_sudq_ft_pd_lv  "IO full speed, PD=40kOhm - 1P8V"
iofs8p_sudq_ft_pu_lv  "IO full speed, PU=40kOhm - 1P8V"
iofs8p_sudq_ft_lv  "IO full speed - 1P8V"
iofs8p_sudq_ft_pd  "IO full speed, PD=40kOhm - 3P3V"
iofs8p_sudq_ft_pu  "IO full speed, PU=40kOhm - 3P3V"
iofs8p_sudq_ft  "IO full speed - 3P3V"
ioms8p_sudq_ft_pd_lv  "IO medium speed, PD=40kOhm - 1P8V"
ioms8p_sudq_ft_pu_lv  "IO medium speed, PU=40kOhm - 1P8V"
ioms8p_sudq_ft_lv  "IO medium speed - 1P8V"
ioms8p_sudq_ft_pd  "IO medium speed, PD=40kOhm - 3P3V"
ioms8p_sudq_ft_pu  "IO medium speed, PU=40kOhm - 3P3V"
ioms8p_sudq_ft  "IO medium speed - 3P3V"
iohs8p_sudq_ft_pd_lv  "IO high speed, PD=40kOhm - 1P8V"
iohs8p_sudq_ft_pu_lv  "IO high speed, PU=40kOhm - 1P8V"
iohs8p_sudq_ft_lv  "IO high speed - 1P8V"
iohs8p_sudq_ft_pd  "IO high speed, PD=40kOhm - 3P3V"
iohs8p_sudq_ft_pu  "IO high speed, PU=40kOhm - 3P3V"
iohs8p_sudq_ft  "IO high speed - 3P3V"
[Model Selector] io8usblsfs_otg2
usb_ls_pd  "USB Low Speed mode - Pull Down"
usb_ls_pu2  "USB Low Speed mode - Pull up 2"
usb_ls_pu  "USB Low Speed mode - Pull up"
usb_fs  "USB Low Speed mode"
usb_fs_pd  "USB Full Speed mode - Pull Down"
usb_fs_pu2  "USB Full Speed mode - Pull up 2"
usb_fs_pu  "USB Full Speed mode - Pull up"
[Model Selector] ioreset_ft_v33
ioreset_1v2_pu  "RESET 1.2V range with PU"
ioreset_1v2  "RESET 1.2V range"
ioreset_1v8_pu  "RESET 1.8V range with PU"
ioreset_1v8  "RESET 1.8V range"
ioreset_3v3_pu  "RESET 3.3V range with PU"
ioreset_3v3  "RESET 3.3V range"
[Define Package Model]  stm32g431_441_lqfp_80
[Manufacturer]  Unknown
[OEM]  Unknown
[Description]  None
[Number Of Pins]  76
[Pin Numbers]
| Pin Num   Terminal Name
12 | PA0
13 | PA1
14 | PA2
17 | PA3
18 | PA4
19 | PA5
20 | PA6
21 | PA7
56 | PA8
57 | PA9
58 | PA10
59 | PA11
60 | PA12
63 | PA13
64 | PA14
65 | PA15
24 | PB0
25 | PB1
26 | PB2
72 | PB3
73 | PB4
74 | PB5
75 | PB6
76 | PB7
77 | PB8
78 | PB9
39 | PB10
42 | PB11
43 | PB12
44 | PB13
45 | PB14
46 | PB15
8 | PC0
9 | PC1
10 | PC2
11 | PC3
22 | PC4
23 | PC5
52 | PC6
53 | PC7
54 | PC8
55 | PC9
66 | PC10
67 | PC11
68 | PC12
2 | PC13
3 | PC14
4 | PC15
69 | PD0
70 | PD1
71 | PD2
47 | PD8
48 | PD9
49 | PD10
30 | PE7
31 | PE8
32 | PE9
33 | PE10
34 | PE11
35 | PE12
36 | PE13
37 | PE14
38 | PE15
5 | PF0
6 | PF1
7 | PG10
1 | VBAT
16 | VDD
41 | VDD
51 | VDD
62 | VDD
80 | VDD
29 | VDDA
28 | VREFP
15 | VSS
27 | VSSA
|[Merged Pins]  15
|40  |  VSS
|50  |  VSS
|61  |  VSS
|79  |  VSS
[Model Data]
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[End Model Data]
[End Package Model]
| Models and submodels in the file (66): usb_bmc_emit_pdccpd (I/O), usb_bmc_emit_pdcc3a0 (I/O), usb_bmc_emit_pdcc1a5 (I/O), usb_bmc_emit_pdccusb (I/O), usb_bmc_emit (I/O), io2_pdcc_ft_3v3_lowspeed (I/O), io2_pdcc_ft_3v3_mediumspeed (I/O), io2_pdcc_ft_3v3_lowspeed_pu (I/O), io2_pdcc_ft_3v3_mediumspeed_pu (I/O), io2_pdcc_ft_3v3_lowspeed_pd (I/O), io2_pdcc_ft_3v3_mediumspeed_pd (I/O), io2_pdcc_ft_1v8_lowspeed (I/O), io2_pdcc_ft_1v8_mediumspeed (I/O), io2_pdcc_ft_1v8_lowspeed_pu (I/O), io2_pdcc_ft_1v8_mediumspeed_pu (I/O), io2_pdcc_ft_1v8_lowspeed_pd (I/O), io2_pdcc_ft_1v8_mediumspeed_pd (I/O), io2_pdcc_ft_1v2_lowspeed (I/O), io2_pdcc_ft_1v2_mediumspeed (I/O), io2_pdcc_ft_1v2_lowspeed_pu (I/O), io2_pdcc_ft_1v2_mediumspeed_pu (I/O), io2_pdcc_ft_1v2_lowspeed_pd (I/O), io2_pdcc_ft_1v2_mediumspeed_pd (I/O), iols8p_sudq_ft_pd_lv (I/O), iols8p_sudq_ft_pu_lv (I/O), iols8p_sudq_ft_lv (I/O), iols8p_sudq_ft_pd (I/O), iols8p_sudq_ft_pu (I/O), iols8p_sudq_ft (I/O), iofs8p_sudq_ft_pd_lv (I/O), iofs8p_sudq_ft_pu_lv (I/O), iofs8p_sudq_ft_lv (I/O), iofs8p_sudq_ft_pd (I/O), iofs8p_sudq_ft_pu (I/O), iofs8p_sudq_ft (I/O), ioms8p_sudq_ft_pd_lv (I/O), ioms8p_sudq_ft_pu_lv (I/O), ioms8p_sudq_ft_lv (I/O), ioms8p_sudq_ft_pd (I/O), ioms8p_sudq_ft_pu (I/O), ioms8p_sudq_ft (I/O), iohs8p_sudq_ft_pd_lv (I/O), iohs8p_sudq_ft_pu_lv (I/O), iohs8p_sudq_ft_lv (I/O), iohs8p_sudq_ft_pd (I/O), iohs8p_sudq_ft_pu (I/O), iohs8p_sudq_ft (I/O), io8prog_1v8_i2c_pd (I/O), io8prog_1v8_i2c_pu (I/O), io8prog_1v8_i2c (I/O), io8prog_3v3_i2c_pd (I/O), io8prog_3v3_i2c_pu (I/O), io8prog_3v3_i2c (I/O), usb_ls_pd (I/O), usb_ls_pu2 (I/O), usb_ls_pu (I/O), usb_fs (I/O), usb_fs_pd (I/O), usb_fs_pu2 (I/O), usb_fs_pu (I/O), ioreset_1v2_pu (I/O_open_drain), ioreset_1v2 (I/O_open_drain), ioreset_1v8_pu (I/O_open_drain), ioreset_1v8 (I/O_open_drain), ioreset_3v3_pu (I/O_open_drain), ioreset_3v3 (I/O_open_drain)
