| IBIS file stm32g491_4a1_lqfp100.ibs
[IBIS ver] 4.2
[File name] stm32g491_4a1_lqfp100.ibs
[File Rev] 1.0
[Date]  29-07-2024
[Source] Data Created at STMicroelectronics
[Notes]  File originated from ELDO simulations.
[Disclaimer]  This information is for modeling purpose only and is
   not guaranteed. The information is subject to change without
   notice.
[Copyright] Copyright 2024 STMicroelectronics Inc.
|   Component stm32g491_4a1_lqfp100
[Component] stm32g491_4a1_lqfp100
[Manufacturer] STMicroelectronics
[Package]
| variable   typ   min   max
R_pkg  0  NA  NA
L_pkg  0  NA  NA
C_pkg  0  NA  NA
[Pin]   signal_name   model_name R_pin  L_pin C_pin
1 PE2 io8prog2m25m50m120m_sudq_ft 0.132430474 7.03397E-09 1.35E-13
2 PE3 io8prog2m25m50m120m_sudq_ft 0.133347678 6.76535E-09 1.95E-14
3 PE4 io8prog2m25m50m120m_sudq_ft 0.12897311 6.4945E-09 1.04E-14
4 PE5 io8prog2m25m50m120m_sudq_ft 0.125344562 6.20552E-09 5.24E-15
5 PE6 io8prog2m25m50m120m_sudq_ft 0.120515446 5.99116E-09 7.82E-15
6 VBAT POWER 0.12047071 5.94998E-09 6.53E-15
7 PC13 io8prog2m25m50m120m_sudq_i2c_ft 0.117880646 5.78336E-09 6.23E-15
8 PC14-OSC32_IN io8prog2m25m50m120m_sudq_i2c_ft 0.117278614 5.65387E-09 3.11E-15
9 PC15-OSC32_OUT io8prog2m25m50m120m_sudq_ft 0.11554812 5.54782E-09 1.39E-15
10 PF9 io8prog2m25m50m120m_sudq_ft 0.114995632 5.4344E-09 2.92E-15
11 PF10 io8prog2m25m50m120m_sudq_ft 0.112975638 5.2963E-09 3.56E-15
12 PF0-OSC_IN io8prog2m25m50m120m_sudq_ft 0.111323436 5.23061E-09 4.78E-15
13 PF1-OSC_OUT io8prog2m25m50m120m_sudq_ft 0.109216856 5.14191E-09 8.66E-15
14 PG10-NRST ioreset_ft_v33 0.11066442 5.17991E-09 9.03E-15
15 PC0 io8prog2m25m50m120m_sudq_ft 0.110607546 5.19248E-09 7.98E-15
16 PC1 io8prog2m25m50m120m_sudq_ft 0.111326184 5.25166E-09 1.03E-14
17 PC2 io8prog2m25m50m120m_sudq_ft 0.11442005 5.34504E-09 7E-15
18 PC3 io8prog2m25m50m120m_sudq_ft 0.114363236 5.45423E-09 8.65E-15
19 PF2 io8prog2m25m50m120m_sudq_ft 0.117563732 5.62144E-09 7.825E-15
20 PA0 io8prog2m25m50m120m_sudq_ft 0.119904688 5.80037E-09 2.29E-16
21 PA1 io8prog2m25m50m120m_sudq_ft 0.122311852 5.96269E-09 1.05E-15
22 PA2 io8prog2m25m50m120m_sudq_ft 0.125384354 6.18685E-09 8.12E-16
23 VSS GND 0.129702038 6.48502E-09 3.82E-15
24 VDD POWER 0.13229018 6.71495E-09 6.8E-15
25 PA3 io8prog2m25m50m120m_sudq_ft 0.132955142 7.01353E-09 1.67E-14
26 PA4 io8prog2m25m50m120m_sudq_ft 0.13394318 7.04988E-09 1.75E-14
27 PA5 io8prog2m25m50m120m_sudq_ft 0.13495773 6.80443E-09 1.27E-14
28 PA6 io8prog2m25m50m120m_sudq_ft 0.130511464 6.52834E-09 9.83E-15
29 PA7 io8prog2m25m50m120m_sudq_ft 0.1253867 6.24489E-09 6.07E-15
30 PC4 io8prog2m25m50m120m_sudq_ft 0.124988978 6.10766E-09 5.77E-16
31 PC5 io8prog2m25m50m120m_sudq_ft 0.121784338 5.89035E-09 1.52E-15
32 PB0 io8prog2m25m50m120m_sudq_ft 0.119149388 5.71642E-09 5.44E-15
33 PB1 io8prog2m25m50m120m_sudq_ft 0.116374808 5.55629E-09 4.1E-15
34 PB2 io8prog2m25m50m120m_sudq_ft 0.113278606 5.41493E-09 3.69E-15
35 VSSA GND 0.112726654 5.35765E-09 3.895E-15
36 VREF+ POWER 0.112271006 5.27162E-09 1.66E-15
37 VDDA POWER 0.111816114 5.23836E-09 7.92E-15
38 PE7 io8prog2m25m50m120m_sudq_ft 0.110998514 5.1839E-09 9.9E-15
39 PE8 io8prog2m25m50m120m_sudq_ft 0.114588522 5.29925E-09 7.91E-15
40 PE9 io8prog2m25m50m120m_sudq_ft 0.114461118 5.33298E-09 7.94E-15
41 PE10 io8prog2m25m50m120m_sudq_ft 0.11535023 5.42422E-09 4.18E-15
42 PE11 io8prog2m25m50m120m_sudq_ft 0.116979452 5.53296E-09 6.06E-15
43 PE12 io8prog2m25m50m120m_sudq_ft 0.120184998 5.69823E-09 5.12E-15
44 PE13 io8prog2m25m50m120m_sudq_ft 0.12258702 5.87093E-09 4.74E-15
45 PE14 io8prog2m25m50m120m_sudq_ft 0.126303358 6.06896E-09 1.16E-14
46 PE15 io8prog2m25m50m120m_sudq_ft 0.129714658 6.27741E-09 9.91E-15
47 PB10 io8prog2m25m50m120m_sudq_ft 0.133373154 6.50819E-09 5.08E-15
48 VSS GND 0.137888146 6.85669E-09 5.47E-15
49 VDD POWER 0.131554082 6.80212E-09 4.18E-15
50 PB11 io8prog2m25m50m120m_sudq_ft 0.132347744 7.042E-09 1.19E-14
51 PB12 io8prog2m25m50m120m_sudq_ft 0.131767814 7.00793E-09 1.62E-14
52 PB13 io8prog2m25m50m120m_sudq_ft 0.131784366 6.75141E-09 2.15E-15
53 PB14 io8prog2m25m50m120m_sudq_ft 0.129150704 6.4828E-09 9.175E-15
54 PB15 io8prog2m25m50m120m_sudq_ft 0.12519135 6.20179E-09 5.6625E-15
55 PD8 io8prog2m25m50m120m_sudq_ft 0.121530258 5.98564E-09 3.69E-15
56 PD9 io8prog2m25m50m120m_sudq_ft 0.11887369 5.8072E-09 7.43E-15
57 PD10 io8prog2m25m50m120m_sudq_ft 0.11586992 5.63548E-09 1.06E-14
58 PD11 io8prog2m25m50m120m_sudq_ft 0.113225758 5.47094E-09 5.76E-15
59 PD12 io8prog2m25m50m120m_sudq_ft 0.111781608 5.35435E-09 6.53E-15
60 PD13 io8prog2m25m50m120m_sudq_ft 0.110712606 5.27649E-09 1.14E-14
61 PD14 io8prog2m25m50m120m_sudq_ft 0.110051596 5.20449E-09 1.32E-14
62 PD15 io8prog2m25m50m120m_sudq_ft 0.10995365 5.1798E-09 1.46E-14
63 VSS GND 0.1097803 5.15375E-09 7.25E-15
64 VDD POWER 0.112445854 5.25828E-09 3.59E-16
65 PC6 io8prog2m25m50m120m_sudq_i2c_ft 0.113595842 5.33176E-09 6.58E-16
66 PC7 io8prog2m25m50m120m_sudq_i2c_ft 0.115707136 5.46645E-09 5.085E-16
67 PC8 io8prog2m25m50m120m_sudq_i2c_ft 0.116952062 5.5984E-09 5.8325E-16
68 PC9 io8prog2m25m50m120m_sudq_i2c_ft 0.11904328 5.76171E-09 5.45875E-16
69 PA8 io8prog2m25m50m120m_sudq_ft 0.120673854 5.87972E-09 1.39E-14
70 PA9 io8prog2m25m50m120m_sudq_i2c_ft 0.124658692 6.10781E-09 2.5E-14
71 PA10 io8prog2m25m50m120m_sudq_ft 0.124406978 6.16144E-09 3.99E-14
72 PA11 io8usblsfs_otg2 0.130155984 6.40391E-09 3.02E-13
73 PA12 io8usblsfs_otg2 0.135109698 6.82357E-09 1.55E-13
74 VSS GND 0.139401952 7.07731E-09 1.55E-13
75 VDD POWER 0.133554014 7.05568E-09 3.9E-14
76 PA13 io8prog2m25m50m120m_sudq_i2c_ft 0.135294596 7.10432E-09 1.63E-14
77 PA14 io8prog2m25m50m120m_sudq_ft 0.132513704 6.8361E-09 9.76E-15
78 PA15 io8prog2m25m50m120m_sudq_i2c_ft 0.133481516 6.64112E-09 9.3E-15
79 PC10 io8prog2m25m50m120m_sudq_ft 0.12836612 6.34148E-09 5.42E-15
80 PC11 io8prog2m25m50m120m_sudq_i2c_ft 0.124282386 6.09211E-09 1.18E-15
81 PC12 io8prog2m25m50m120m_sudq_ft 0.121841172 5.91673E-09 5.46E-15
82 PD0 io8prog2m25m50m120m_sudq_ft 0.118487054 5.72844E-09 7E-15
83 PD1 io8prog2m25m50m120m_sudq_ft 0.117180194 5.57316E-09 6.06E-15
84 PD2 io8prog2m25m50m120m_sudq_ft 0.11350052 5.42154E-09 5.45E-15
85 PD3 io8prog2m25m50m120m_sudq_ft 0.113789098 5.34394E-09 5.29E-16
86 PD4 io8prog2m25m50m120m_sudq_ft 0.110805858 5.25639E-09 2.9895E-15
87 PD5 io8prog2m25m50m120m_sudq_ft 0.110442376 5.2462E-09 2.06E-15
88 PD6 io8prog2m25m50m120m_sudq_ft 0.111525472 5.17788E-09 5.68E-15
89 PD7 io8prog2m25m50m120m_sudq_ft 0.11114441 5.22307E-09 9.91E-15
90 PB3 io8prog2m25m50m120m_sudq_ft 0.113222316 5.31007E-09 9.05E-15
91 PB4 io6usb_bmc_pd_cc_ft 0.113322882 5.40053E-09 1.29E-14
92 PB5 io8prog2m25m50m120m_sudq_ft 0.1158486 5.51866E-09 1.26E-14
93 PB6 io6usb_bmc_pd_cc_ft 0.117577758 5.67321E-09 6.14E-15
94 PB7 io8prog2m25m50m120m_sudq_i2c_ft 0.1189821 5.80207E-09 9.37E-15
95 PB8-BOOT0 io8prog2m25m50m120m_sudq_i2c_ft 0.121885942 5.96185E-09 7.755E-15
96 PB9 io8prog2m25m50m120m_sudq_i2c_ft 0.126275558 6.15795E-09 8.5625E-15
97 PE0 io8prog2m25m50m120m_sudq_ft 0.128749356 6.36737E-09 8.15875E-15
98 PE1 io8prog2m25m50m120m_sudq_ft 0.13328845 6.70016E-09 1.03E-15
99 VSS GND 0.13223018 6.84396E-09 4.41E-15
100 VDD POWER 0.132277204 7.05248E-09 1.71E-14
[Model Selector] io6usb_bmc_pd_cc_ft
usb_bmc_emit_pdccpd  "BMC PD emitter  + PD"
usb_bmc_emit_pdcc3a0  "BMC PD emitter  + 3rd PU"
usb_bmc_emit_pdcc1a5  "BMC PD emitter  + 2nd PU"
usb_bmc_emit_pdccusb  "BMC PD emitter  + 1st PU"
usb_bmc_emit  "BMC PD emitter "
io2_pdcc_ft_3v3_lowspeed  "GPIO-3.3V range - low speed"
io2_pdcc_ft_3v3_mediumspeed  "GPIO-3.3V range - medium speed"
io2_pdcc_ft_3v3_lowspeed_pu  "GPIO-3.3V range - low speed - pull up"
io2_pdcc_ft_3v3_mediumspeed_pu  "GPIO-3.3V range - medium speed - pull up"
io2_pdcc_ft_3v3_lowspeed_pd  "GPIO-3.3V range - low speed - pull down"
io2_pdcc_ft_3v3_mediumspeed_pd  "GPIO-3.3V range - medium speed - pull down"
io2_pdcc_ft_1v8_lowspeed  "GPIO-1.8V range - low speed"
io2_pdcc_ft_1v8_mediumspeed  "GPIO-1.8V range - medium speed"
io2_pdcc_ft_1v8_lowspeed_pu  "GPIO-1.8V range - low speed - pull up"
io2_pdcc_ft_1v8_mediumspeed_pu  "GPIO-1.8V range - medium speed - pull up"
io2_pdcc_ft_1v8_lowspeed_pd  "GPIO-1.8V range - low speed - pull down"
io2_pdcc_ft_1v8_mediumspeed_pd  "GPIO-1.8V range - medium speed - pull down"
io2_pdcc_ft_1v2_lowspeed  "GPIO-1.2V range - low speed"
io2_pdcc_ft_1v2_mediumspeed  "GPIO-1.2V range - medium speed"
io2_pdcc_ft_1v2_lowspeed_pu  "GPIO-1.2V range - low speed - pull up"
io2_pdcc_ft_1v2_mediumspeed_pu  "GPIO-1.2V range - medium speed - pull up"
io2_pdcc_ft_1v2_lowspeed_pd  "GPIO-1.2V range - low speed - pull down"
io2_pdcc_ft_1v2_mediumspeed_pd  "GPIO-1.2V range - medium speed - pull down"
[Model Selector] io8prog2m25m50m120m_sudq_ft
iols8p_sudq_ft_pd_lv  "IO low speed, PD=40kOhm - 1P8V"
iols8p_sudq_ft_pu_lv  "IO low speed, PU=40kOhm - 1P8V"
iols8p_sudq_ft_lv  "IO low speed - 1P8V"
iols8p_sudq_ft_pd  "IO low speed, PD=40kOhm - 3P3V"
iols8p_sudq_ft_pu  "IO low speed, PU=40kOhm - 3P3V"
iols8p_sudq_ft  "IO low speed - 3P3V"
iofs8p_sudq_ft_pd_lv  "IO full speed, PD=40kOhm - 1P8V"
iofs8p_sudq_ft_pu_lv  "IO full speed, PU=40kOhm - 1P8V"
iofs8p_sudq_ft_lv  "IO full speed - 1P8V"
iofs8p_sudq_ft_pd  "IO full speed, PD=40kOhm - 3P3V"
iofs8p_sudq_ft_pu  "IO full speed, PU=40kOhm - 3P3V"
iofs8p_sudq_ft  "IO full speed - 3P3V"
ioms8p_sudq_ft_pd_lv  "IO medium speed, PD=40kOhm - 1P8V"
ioms8p_sudq_ft_pu_lv  "IO medium speed, PU=40kOhm - 1P8V"
ioms8p_sudq_ft_lv  "IO medium speed - 1P8V"
ioms8p_sudq_ft_pd  "IO medium speed, PD=40kOhm - 3P3V"
ioms8p_sudq_ft_pu  "IO medium speed, PU=40kOhm - 3P3V"
ioms8p_sudq_ft  "IO medium speed - 3P3V"
iohs8p_sudq_ft_pd_lv  "IO high speed, PD=40kOhm - 1P8V"
iohs8p_sudq_ft_pu_lv  "IO high speed, PU=40kOhm - 1P8V"
iohs8p_sudq_ft_lv  "IO high speed - 1P8V"
iohs8p_sudq_ft_pd  "IO high speed, PD=40kOhm - 3P3V"
iohs8p_sudq_ft_pu  "IO high speed, PU=40kOhm - 3P3V"
iohs8p_sudq_ft  "IO high speed - 3P3V"
[Model Selector] io8prog2m25m50m120m_sudq_i2c_ft
io8prog_1v8_i2c_pd  "5V Tol GPIO 1.8V range i2c functionality with pull down"
io8prog_1v8_i2c_pu  "5V Tol GPIO 1.8V range i2c functionality with pull up"
io8prog_1v8_i2c  "5V Tol GPIO 1.8V range i2c functionality"
io8prog_3v3_i2c_pd  "5V Tol GPIO 3.3V range i2c functionality with pull down"
io8prog_3v3_i2c_pu  "5V Tol GPIO 3.3V range i2c functionality with pull up"
io8prog_3v3_i2c  "5V Tol GPIO 3.3V range i2c functionality"
iols8p_sudq_ft_pd_lv  "IO low speed, PD=40kOhm - 1P8V"
iols8p_sudq_ft_pu_lv  "IO low speed, PU=40kOhm - 1P8V"
iols8p_sudq_ft_lv  "IO low speed - 1P8V"
iols8p_sudq_ft_pd  "IO low speed, PD=40kOhm - 3P3V"
iols8p_sudq_ft_pu  "IO low speed, PU=40kOhm - 3P3V"
iols8p_sudq_ft  "IO low speed - 3P3V"
iofs8p_sudq_ft_pd_lv  "IO full speed, PD=40kOhm - 1P8V"
iofs8p_sudq_ft_pu_lv  "IO full speed, PU=40kOhm - 1P8V"
iofs8p_sudq_ft_lv  "IO full speed - 1P8V"
iofs8p_sudq_ft_pd  "IO full speed, PD=40kOhm - 3P3V"
iofs8p_sudq_ft_pu  "IO full speed, PU=40kOhm - 3P3V"
iofs8p_sudq_ft  "IO full speed - 3P3V"
ioms8p_sudq_ft_pd_lv  "IO medium speed, PD=40kOhm - 1P8V"
ioms8p_sudq_ft_pu_lv  "IO medium speed, PU=40kOhm - 1P8V"
ioms8p_sudq_ft_lv  "IO medium speed - 1P8V"
ioms8p_sudq_ft_pd  "IO medium speed, PD=40kOhm - 3P3V"
ioms8p_sudq_ft_pu  "IO medium speed, PU=40kOhm - 3P3V"
ioms8p_sudq_ft  "IO medium speed - 3P3V"
iohs8p_sudq_ft_pd_lv  "IO high speed, PD=40kOhm - 1P8V"
iohs8p_sudq_ft_pu_lv  "IO high speed, PU=40kOhm - 1P8V"
iohs8p_sudq_ft_lv  "IO high speed - 1P8V"
iohs8p_sudq_ft_pd  "IO high speed, PD=40kOhm - 3P3V"
iohs8p_sudq_ft_pu  "IO high speed, PU=40kOhm - 3P3V"
iohs8p_sudq_ft  "IO high speed - 3P3V"
[Model Selector] io8usblsfs_otg2
usb_ls_pd  "USB Low Speed mode - Pull Down"
usb_ls_pu2  "USB Low Speed mode - Pull up 2"
usb_ls_pu  "USB Low Speed mode - Pull up"
usb_fs  "USB Low Speed mode"
usb_fs_pd  "USB Full Speed mode - Pull Down"
usb_fs_pu2  "USB Full Speed mode - Pull up 2"
usb_fs_pu  "USB Full Speed mode - Pull up"
[Model Selector] ioreset_ft_v33
ioreset_1v2_pu  "RESET 1.2V range with PU"
ioreset_1v2  "RESET 1.2V range"
ioreset_1v8_pu  "RESET 1.8V range with PU"
ioreset_1v8  "RESET 1.8V range"
ioreset_3v3_pu  "RESET 3.3V range with PU"
ioreset_3v3  "RESET 3.3V range"
| Models and submodels in the file (66): usb_bmc_emit_pdccpd (I/O), usb_bmc_emit_pdcc3a0 (I/O), usb_bmc_emit_pdcc1a5 (I/O), usb_bmc_emit_pdccusb (I/O), usb_bmc_emit (I/O), io2_pdcc_ft_3v3_lowspeed (I/O), io2_pdcc_ft_3v3_mediumspeed (I/O), io2_pdcc_ft_3v3_lowspeed_pu (I/O), io2_pdcc_ft_3v3_mediumspeed_pu (I/O), io2_pdcc_ft_3v3_lowspeed_pd (I/O), io2_pdcc_ft_3v3_mediumspeed_pd (I/O), io2_pdcc_ft_1v8_lowspeed (I/O), io2_pdcc_ft_1v8_mediumspeed (I/O), io2_pdcc_ft_1v8_lowspeed_pu (I/O), io2_pdcc_ft_1v8_mediumspeed_pu (I/O), io2_pdcc_ft_1v8_lowspeed_pd (I/O), io2_pdcc_ft_1v8_mediumspeed_pd (I/O), io2_pdcc_ft_1v2_lowspeed (I/O), io2_pdcc_ft_1v2_mediumspeed (I/O), io2_pdcc_ft_1v2_lowspeed_pu (I/O), io2_pdcc_ft_1v2_mediumspeed_pu (I/O), io2_pdcc_ft_1v2_lowspeed_pd (I/O), io2_pdcc_ft_1v2_mediumspeed_pd (I/O), iols8p_sudq_ft_pd_lv (I/O), iols8p_sudq_ft_pu_lv (I/O), iols8p_sudq_ft_lv (I/O), iols8p_sudq_ft_pd (I/O), iols8p_sudq_ft_pu (I/O), iols8p_sudq_ft (I/O), iofs8p_sudq_ft_pd_lv (I/O), iofs8p_sudq_ft_pu_lv (I/O), iofs8p_sudq_ft_lv (I/O), iofs8p_sudq_ft_pd (I/O), iofs8p_sudq_ft_pu (I/O), iofs8p_sudq_ft (I/O), ioms8p_sudq_ft_pd_lv (I/O), ioms8p_sudq_ft_pu_lv (I/O), ioms8p_sudq_ft_lv (I/O), ioms8p_sudq_ft_pd (I/O), ioms8p_sudq_ft_pu (I/O), ioms8p_sudq_ft (I/O), iohs8p_sudq_ft_pd_lv (I/O), iohs8p_sudq_ft_pu_lv (I/O), iohs8p_sudq_ft_lv (I/O), iohs8p_sudq_ft_pd (I/O), iohs8p_sudq_ft_pu (I/O), iohs8p_sudq_ft (I/O), io8prog_1v8_i2c_pd (I/O_open_drain), io8prog_1v8_i2c_pu (I/O_open_drain), io8prog_1v8_i2c (I/O_open_drain), io8prog_3v3_i2c_pd (I/O_open_drain), io8prog_3v3_i2c_pu (I/O_open_drain), io8prog_3v3_i2c (I/O_open_drain), usb_ls_pd (I/O), usb_ls_pu2 (I/O), usb_ls_pu (I/O), usb_fs (I/O), usb_fs_pd (I/O), usb_fs_pu2 (I/O), usb_fs_pu (I/O), ioreset_1v2_pu (I/O_open_drain), ioreset_1v2 (I/O_open_drain), ioreset_1v8_pu (I/O_open_drain), ioreset_1v8 (I/O_open_drain), ioreset_3v3_pu (I/O_open_drain), ioreset_3v3 (I/O_open_drain)
