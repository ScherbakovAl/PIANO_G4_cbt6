| IBIS file stm32g471_473_474_483_484_lqfp128.ibs
[IBIS ver]   4.2
[File name]  stm32g471_473_474_483_484_lqfp128.ibs
[File Rev]   1.0
[Date]   08-07-2019
[Source]   Data Created at STMicroelectronics
[Notes]   File originated from ELDO simulations.
[Disclaimer] This information is for modeling purpose only and is
   not guaranted. The information is subject to change without
   notice.
[Copyright]  Copyright 2019 STMicroelectronics Inc.
|   Component stm32g471_473_474_483_484_lqfp128
[Component] stm32g471_473_474_483_484_lqfp128
[Manufacturer] STMicroelectronics
[Package]
| variable   typ   min   max
R_pkg  0  NA  NA
L_pkg  0  NA  NA
C_pkg  0  NA  NA
[Pin]   signal_name   model_name
1  PE2  io8prog2m25m50m120m_sudq_ft
2  PE3  io8prog2m25m50m120m_sudq_ft
3  PE4  io8prog2m25m50m120m_sudq_ft
4  PE5  io8prog2m25m50m120m_sudq_ft
5  PE6  io8prog2m25m50m120m_sudq_ft
6  VBAT  power
7  PC13  io8prog2m25m50m120m_sudq_ft
8  PC14-OSC32_IN  io8prog2m25m50m120m_sudq_ft
9  PC15-OSC32_OUT  io8prog2m25m50m120m_sudq_ft
10  PF3  io8prog2m25m50m120m_sudq_i2c_ft
11  PF4  io8prog2m25m50m120m_sudq_i2c_ft
12  VSS  gnd
13  VDD  power
14  PF5  io8prog2m25m50m120m_sudq_ft
15  PF7  io8prog2m25m50m120m_sudq_ft
16  PF8  io8prog2m25m50m120m_sudq_ft
17  PF9  io8prog2m25m50m120m_sudq_ft
18  PF10  io8prog2m25m50m120m_sudq_ft
19  PF0-OSC_IN  io8prog2m25m50m120m_sudq_i2c_ft
20  PF1-OSC_OUT  io8prog2m25m50m120m_sudq_ft
21  PG10-NRST  ioreset_ft_v33
22  PC0  io8prog2m25m50m120m_sudq_ft
23  PC1  io8prog2m25m50m120m_sudq_ft
24  PC2  io8prog2m25m50m120m_sudq_ft
25  PC3  io8prog2m25m50m120m_sudq_ft
26  PF2  io8prog2m25m50m120m_sudq_ft
27  PA0  io8prog2m25m50m120m_sudq_ft
28  PA1  io8prog2m25m50m120m_sudq_ft
29  PA2  io8prog2m25m50m120m_sudq_ft
30  VSS  gnd
31  VDD  power
32  PA3  io8prog2m25m50m120m_sudq_ft
33  PA4  io8prog2m25m50m120m_sudq_ft
34  PA5  io8prog2m25m50m120m_sudq_ft
35  PA6  io8prog2m25m50m120m_sudq_ft
36  PA7  io8prog2m25m50m120m_sudq_ft
37  PC4  io8prog2m25m50m120m_sudq_i2c_ft
38  PC5  io8prog2m25m50m120m_sudq_ft
39  PB0  io8prog2m25m50m120m_sudq_ft
40  PB1  io8prog2m25m50m120m_sudq_ft
41  PB2  io8prog2m25m50m120m_sudq_ft
42  VSSA  nc
43  VREF+  nc
44  VREF+  nc
45  VDDA  nc
46  VSS  gnd
47  VDD  power
48  PF11  io8prog2m25m50m120m_sudq_ft
49  PF12  io8prog2m25m50m120m_sudq_ft
50  PF13  io8prog2m25m50m120m_sudq_ft
51  PF14  io8prog2m25m50m120m_sudq_i2c_ft
52  PF15  io8prog2m25m50m120m_sudq_i2c_ft
53  PE7  io8prog2m25m50m120m_sudq_ft
54  PE8  io8prog2m25m50m120m_sudq_ft
55  PE9  io8prog2m25m50m120m_sudq_ft
56  PE10  io8prog2m25m50m120m_sudq_ft
57  PE11  io8prog2m25m50m120m_sudq_ft
58  PE12  io8prog2m25m50m120m_sudq_ft
59  PE13  io8prog2m25m50m120m_sudq_ft
60  PE14  io8prog2m25m50m120m_sudq_ft
61  PE15  io8prog2m25m50m120m_sudq_ft
62  PB10  io8prog2m25m50m120m_sudq_ft
63  VSS  gnd
64  VDD  power
65  PB11  io8prog2m25m50m120m_sudq_ft
66  PB12  io8prog2m25m50m120m_sudq_ft
67  PB13  io8prog2m25m50m120m_sudq_ft
68  PB14  io8prog2m25m50m120m_sudq_ft
69  PB15  io8prog2m25m50m120m_sudq_ft
70  PD8  io8prog2m25m50m120m_sudq_ft
71  PD9  io8prog2m25m50m120m_sudq_ft
72  PD10  io8prog2m25m50m120m_sudq_ft
73  PD11  io8prog2m25m50m120m_sudq_ft
74  PD12  io8prog2m25m50m120m_sudq_ft
75  PD13  io8prog2m25m50m120m_sudq_ft
76  PD14  io8prog2m25m50m120m_sudq_ft
77  PD15  io8prog2m25m50m120m_sudq_ft
78  VSS  gnd
79  VDD  power
80  PC6  io8prog2m25m50m120m_sudq_i2c_ft
81  PC7  io8prog2m25m50m120m_sudq_i2c_ft
82  PG0  io8prog2m25m50m120m_sudq_ft
83  PG1  io8prog2m25m50m120m_sudq_ft
84  PG2  io8prog2m25m50m120m_sudq_ft
85  PG3  io8prog2m25m50m120m_sudq_i2c_ft
86  PG4  io8prog2m25m50m120m_sudq_i2c_ft
87  PC8  io8prog2m25m50m120m_sudq_i2c_ft
88  PC9  io8prog2m25m50m120m_sudq_i2c_ft
89  PA8  io8prog2m25m50m120m_sudq_ft
90  PA9  io8prog2m25m50m120m_sudq_i2c_ft
91  PA10  io8prog2m25m50m120m_sudq_i2c_ft
92  PA11  io8usblsfs_otg2
93  PA12  io8usblsfs_otg2
94  VSS  gnd
95  VDD  power
96  PA13  io8prog2m25m50m120m_sudq_i2c_ft
97  PF6  io8prog2m25m50m120m_sudq_i2c_ft
98  PA14  io8prog2m25m50m120m_sudq_i2c_ft
99  PA15  io8prog2m25m50m120m_sudq_i2c_ft
100  PC10  io8prog2m25m50m120m_sudq_ft
101  PC11  io8prog2m25m50m120m_sudq_i2c_ft
102  PC12  io8prog2m25m50m120m_sudq_ft
103  PG5  io8prog2m25m50m120m_sudq_ft
104  PG6  io8prog2m25m50m120m_sudq_ft
105  PG7  io8prog2m25m50m120m_sudq_i2c_ft
106  PG8  io8prog2m25m50m120m_sudq_i2c_ft
107  PG9  io8prog2m25m50m120m_sudq_ft
108  PD0  io8prog2m25m50m120m_sudq_ft
109  PD1  io8prog2m25m50m120m_sudq_ft
110  VSS  gnd
111  VDD  power
112  PD2  io8prog2m25m50m120m_sudq_ft
113  PD3  io8prog2m25m50m120m_sudq_ft
114  PD4  io8prog2m25m50m120m_sudq_ft
115  PD5  io8prog2m25m50m120m_sudq_ft
116  PD6  io8prog2m25m50m120m_sudq_ft
117  PD7  io8prog2m25m50m120m_sudq_ft
118  PB3  io8prog2m25m50m120m_sudq_ft
119  PB4  io6usb_bmc_pd_cc_ft
120  PB5  io8prog2m25m50m120m_sudq_i2c_ft
121  PB6  io6usb_bmc_pd_cc_ft
122  PB7  io8prog2m25m50m120m_sudq_i2c_ft
123  PB8-BOOT0  io8prog2m25m50m120m_sudq_i2c_ft
124  PB9  io8prog2m25m50m120m_sudq_i2c_ft
125  PE0  io8prog2m25m50m120m_sudq_ft
126  PE1  io8prog2m25m50m120m_sudq_ft
127  VSS  gnd
128  VDD  power
[Package Model]   stm32g471_473_474_483_484_lqfp_128
[Pin Mapping]   pulldown_ref   pullup_ref   | Comment
1  gndio  vddio
2  gndio  vddio
3  gndio  vddio
4  gndio  vddio
5  gndio  vddio
6  nc  vswitch
7  gndio  vddio  | Depending on IO usage
| 7  gndio  vswitch  | Depending on IO usage
8  gndio  vddio  | Depending on IO usage
| 8  gndio  vswitch  | Depending on IO usage
9  gndio  vddio  | Depending on IO usage
| 9  gndio  vswitch  | Depending on IO usage
10  gndio  vddio
11  gndio  vddio
12  gndio  nc
13  nc  vddio
14  gndio  vddio
15  gndio  vddio
16  gndio  vddio
17  gndio  vddio
18  gndio  vddio
19  gndio  vddio
20  gndio  vddio
21  gndio  vddio
22  gndio  vddio
23  gndio  vddio
24  gndio  vddio
25  gndio  vddio
26  gndio  vddio
27  gndio  vddio
28  gndio  vddio
29  gndio  vddio
30  gndio  nc
31  nc  vddio
32  gndio  vddio
33  gndio  vddio
34  gndio  vddio
35  gndio  vddio
36  gndio  vddio
37  gndio  vddio
38  gndio  vddio
39  gndio  vddio
40  gndio  vddio
41  gndio  vddio
42  nc  nc
43  nc  nc
44  nc  nc
45  nc  nc
46  gndio  nc
47  nc  vddio
48  gndio  vddio
49  gndio  vddio
50  gndio  vddio
51  gndio  vddio
52  gndio  vddio
53  gndio  vddio
54  gndio  vddio
55  gndio  vddio
56  gndio  vddio
57  gndio  vddio
58  gndio  vddio
59  gndio  vddio
60  gndio  vddio
61  gndio  vddio
62  gndio  vddio
63  gndio  nc
64  nc  vddio
65  gndio  vddio
66  gndio  vddio
67  gndio  vddio
68  gndio  vddio
69  gndio  vddio
70  gndio  vddio
71  gndio  vddio
72  gndio  vddio
73  gndio  vddio
74  gndio  vddio
75  gndio  vddio
76  gndio  vddio
77  gndio  vddio
78  gndio  nc
79  nc  vddio
80  gndio  vddio
81  gndio  vddio
82  gndio  vddio
83  gndio  vddio
84  gndio  vddio
85  gndio  vddio
86  gndio  vddio
87  gndio  vddio
88  gndio  vddio
89  gndio  vddio
90  gndio  vddio
91  gndio  vddio
92  gndio  vddio
93  gndio  vddio
94  gndio  nc
95  nc  vddio
96  gndio  vddio
97  gndio  vddio
98  gndio  vddio
99  gndio  vddio
100  gndio  vddio
101  gndio  vddio
102  gndio  vddio
103  gndio  vddio
104  gndio  vddio
105  gndio  vddio
106  gndio  vddio
107  gndio  vddio
108  gndio  vddio
109  gndio  vddio
110  gndio  nc
111  nc  vddio
112  gndio  vddio
113  gndio  vddio
114  gndio  vddio
115  gndio  vddio
116  gndio  vddio
117  gndio  vddio
118  gndio  vddio
119  gndio  vddio
120  gndio  vddio
121  gndio  vddio
122  gndio  vddio
123  gndio  vddio
124  gndio  vddio
125  gndio  vddio
126  gndio  vddio
127  gndio  nc
128  nc  vddio
[Model Selector] io6usb_bmc_pd_cc_ft
usb_bmc_emit_pdccpd  "BMC PD emitter  + PD"
usb_bmc_emit_pdcc3a0  "BMC PD emitter  + 3rd PU"
usb_bmc_emit_pdcc1a5  "BMC PD emitter  + 2nd PU"
usb_bmc_emit_pdccusb  "BMC PD emitter  + 1st PU"
usb_bmc_emit  "BMC PD emitter "
io2_pdcc_ft_3v3_lowspeed  "GPIO-3.3V range - low speed"
io2_pdcc_ft_3v3_mediumspeed  "GPIO-3.3V range - medium speed"
io2_pdcc_ft_3v3_lowspeed_pu  "GPIO-3.3V range - low speed - pull up"
io2_pdcc_ft_3v3_mediumspeed_pu  "GPIO-3.3V range - medium speed - pull up"
io2_pdcc_ft_3v3_lowspeed_pd  "GPIO-3.3V range - low speed - pull down"
io2_pdcc_ft_3v3_mediumspeed_pd  "GPIO-3.3V range - medium speed - pull down"
io2_pdcc_ft_1v8_lowspeed  "GPIO-1.8V range - low speed"
io2_pdcc_ft_1v8_mediumspeed  "GPIO-1.8V range - medium speed"
io2_pdcc_ft_1v8_lowspeed_pu  "GPIO-1.8V range - low speed - pull up"
io2_pdcc_ft_1v8_mediumspeed_pu  "GPIO-1.8V range - medium speed - pull up"
io2_pdcc_ft_1v8_lowspeed_pd  "GPIO-1.8V range - low speed - pull down"
io2_pdcc_ft_1v8_mediumspeed_pd  "GPIO-1.8V range - medium speed - pull down"
io2_pdcc_ft_1v2_lowspeed  "GPIO-1.2V range - low speed"
io2_pdcc_ft_1v2_mediumspeed  "GPIO-1.2V range - medium speed"
io2_pdcc_ft_1v2_lowspeed_pu  "GPIO-1.2V range - low speed - pull up"
io2_pdcc_ft_1v2_mediumspeed_pu  "GPIO-1.2V range - medium speed - pull up"
io2_pdcc_ft_1v2_lowspeed_pd  "GPIO-1.2V range - low speed - pull down"
io2_pdcc_ft_1v2_mediumspeed_pd  "GPIO-1.2V range - medium speed - pull down"
[Model Selector] io8prog2m25m50m120m_sudq_ft
iols8p_sudq_ft_pd_lv  "IO low speed, PD=40kOhm - 1P8V"
iols8p_sudq_ft_pu_lv  "IO low speed, PU=40kOhm - 1P8V"
iols8p_sudq_ft_lv  "IO low speed - 1P8V"
iols8p_sudq_ft_pd  "IO low speed, PD=40kOhm - 3P3V"
iols8p_sudq_ft_pu  "IO low speed, PU=40kOhm - 3P3V"
iols8p_sudq_ft  "IO low speed - 3P3V"
iofs8p_sudq_ft_pd_lv  "IO full speed, PD=40kOhm - 1P8V"
iofs8p_sudq_ft_pu_lv  "IO full speed, PU=40kOhm - 1P8V"
iofs8p_sudq_ft_lv  "IO full speed - 1P8V"
iofs8p_sudq_ft_pd  "IO full speed, PD=40kOhm - 3P3V"
iofs8p_sudq_ft_pu  "IO full speed, PU=40kOhm - 3P3V"
iofs8p_sudq_ft  "IO full speed - 3P3V"
ioms8p_sudq_ft_pd_lv  "IO medium speed, PD=40kOhm - 1P8V"
ioms8p_sudq_ft_pu_lv  "IO medium speed, PU=40kOhm - 1P8V"
ioms8p_sudq_ft_lv  "IO medium speed - 1P8V"
ioms8p_sudq_ft_pd  "IO medium speed, PD=40kOhm - 3P3V"
ioms8p_sudq_ft_pu  "IO medium speed, PU=40kOhm - 3P3V"
ioms8p_sudq_ft  "IO medium speed - 3P3V"
iohs8p_sudq_ft_pd_lv  "IO high speed, PD=40kOhm - 1P8V"
iohs8p_sudq_ft_pu_lv  "IO high speed, PU=40kOhm - 1P8V"
iohs8p_sudq_ft_lv  "IO high speed - 1P8V"
iohs8p_sudq_ft_pd  "IO high speed, PD=40kOhm - 3P3V"
iohs8p_sudq_ft_pu  "IO high speed, PU=40kOhm - 3P3V"
iohs8p_sudq_ft  "IO high speed - 3P3V"
[Model Selector] io8prog2m25m50m120m_sudq_i2c_ft
io8prog_1v8_i2c_pd  "5V Tol GPIO 1.8V range i2c functionality with pull down"
io8prog_1v8_i2c_pu  "5V Tol GPIO 1.8V range i2c functionality with pull up"
io8prog_1v8_i2c  "5V Tol GPIO 1.8V range i2c functionality"
io8prog_3v3_i2c_pd  "5V Tol GPIO 3.3V range i2c functionality with pull down"
io8prog_3v3_i2c_pu  "5V Tol GPIO 3.3V range i2c functionality with pull up"
io8prog_3v3_i2c  "5V Tol GPIO 3.3V range i2c functionality"
iols8p_sudq_ft_pd_lv  "IO low speed, PD=40kOhm - 1P8V"
iols8p_sudq_ft_pu_lv  "IO low speed, PU=40kOhm - 1P8V"
iols8p_sudq_ft_lv  "IO low speed - 1P8V"
iols8p_sudq_ft_pd  "IO low speed, PD=40kOhm - 3P3V"
iols8p_sudq_ft_pu  "IO low speed, PU=40kOhm - 3P3V"
iols8p_sudq_ft  "IO low speed - 3P3V"
iofs8p_sudq_ft_pd_lv  "IO full speed, PD=40kOhm - 1P8V"
iofs8p_sudq_ft_pu_lv  "IO full speed, PU=40kOhm - 1P8V"
iofs8p_sudq_ft_lv  "IO full speed - 1P8V"
iofs8p_sudq_ft_pd  "IO full speed, PD=40kOhm - 3P3V"
iofs8p_sudq_ft_pu  "IO full speed, PU=40kOhm - 3P3V"
iofs8p_sudq_ft  "IO full speed - 3P3V"
ioms8p_sudq_ft_pd_lv  "IO medium speed, PD=40kOhm - 1P8V"
ioms8p_sudq_ft_pu_lv  "IO medium speed, PU=40kOhm - 1P8V"
ioms8p_sudq_ft_lv  "IO medium speed - 1P8V"
ioms8p_sudq_ft_pd  "IO medium speed, PD=40kOhm - 3P3V"
ioms8p_sudq_ft_pu  "IO medium speed, PU=40kOhm - 3P3V"
ioms8p_sudq_ft  "IO medium speed - 3P3V"
iohs8p_sudq_ft_pd_lv  "IO high speed, PD=40kOhm - 1P8V"
iohs8p_sudq_ft_pu_lv  "IO high speed, PU=40kOhm - 1P8V"
iohs8p_sudq_ft_lv  "IO high speed - 1P8V"
iohs8p_sudq_ft_pd  "IO high speed, PD=40kOhm - 3P3V"
iohs8p_sudq_ft_pu  "IO high speed, PU=40kOhm - 3P3V"
iohs8p_sudq_ft  "IO high speed - 3P3V"
[Model Selector] io8usblsfs_otg2
usb_ls_pd  "USB Low Speed mode - Pull Down"
usb_ls_pu2  "USB Low Speed mode - Pull up 2"
usb_ls_pu  "USB Low Speed mode - Pull up"
usb_fs  "USB Low Speed mode"
usb_fs_pd  "USB Full Speed mode - Pull Down"
usb_fs_pu2  "USB Full Speed mode - Pull up 2"
usb_fs_pu  "USB Full Speed mode - Pull up"
[Model Selector] ioreset_ft_v33
ioreset_1v2_pu  "RESET 1.2V range with PU"
ioreset_1v2  "RESET 1.2V range"
ioreset_1v8_pu  "RESET 1.8V range with PU"
ioreset_1v8  "RESET 1.8V range"
ioreset_3v3_pu  "RESET 3.3V range with PU"
ioreset_3v3  "RESET 3.3V range"
[Define Package Model]  stm32g471_473_474_483_484_lqfp_128
[Manufacturer]  Unknown
[OEM]  Unknown
[Description]  None
[Number Of Pins]  128
[Pin Numbers]
| Pin Num   Terminal Name
27 | PA0
28 | PA1
29 | PA2
32 | PA3
33 | PA4
34 | PA5
35 | PA6
36 | PA7
89 | PA8
90 | PA9
91 | PA10
92 | PA11
93 | PA12
96 | PA13
98 | PA14
99 | PA15
39 | PB0
40 | PB1
41 | PB2
118 | PB3
119 | PB4
120 | PB5
121 | PB6
122 | PB7
124 | PB9
62 | PB10
65 | PB11
66 | PB12
67 | PB13
68 | PB14
69 | PB15
123 | PB8-BOOT0
22 | PC0
23 | PC1
24 | PC2
25 | PC3
37 | PC4
38 | PC5
80 | PC6
81 | PC7
87 | PC8
88 | PC9
100 | PC10
101 | PC11
102 | PC12
7 | PC13
8 | PC14-OSC32_IN
9 | PC15-OSC32_OUT
108 | PD0
109 | PD1
112 | PD2
113 | PD3
114 | PD4
115 | PD5
116 | PD6
117 | PD7
70 | PD8
71 | PD9
72 | PD10
73 | PD11
74 | PD12
75 | PD13
76 | PD14
77 | PD15
125 | PE0
126 | PE1
1 | PE2
2 | PE3
3 | PE4
4 | PE5
5 | PE6
53 | PE7
54 | PE8
55 | PE9
56 | PE10
57 | PE11
58 | PE12
59 | PE13
60 | PE14
61 | PE15
26 | PF2
10 | PF3
11 | PF4
14 | PF5
97 | PF6
15 | PF7
16 | PF8
17 | PF9
18 | PF10
48 | PF11
49 | PF12
50 | PF13
51 | PF14
52 | PF15
19 | PF0-OSC_IN
20 | PF1-OSC_OUT
82 | PG0
83 | PG1
84 | PG2
85 | PG3
86 | PG4
103 | PG5
104 | PG6
105 | PG7
106 | PG8
107 | PG9
21 | PG10-NRST
6 | VBAT
13 | VDD
31 | VDD
47 | VDD
64 | VDD
79 | VDD
95 | VDD
111 | VDD
128 | VDD
45 | VDDA
44 | VREF+
43 | VREF+
12 | VSS
30 | VSS
46 | VSS
63 | VSS
78 | VSS
94 | VSS
110 | VSS
127 | VSS
42 | VSSA
[Model Data]
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[End Model Data]
[End Package Model]
| Models and submodels in the file (66): usb_bmc_emit_pdccpd (I/O), usb_bmc_emit_pdcc3a0 (I/O), usb_bmc_emit_pdcc1a5 (I/O), usb_bmc_emit_pdccusb (I/O), usb_bmc_emit (I/O), io2_pdcc_ft_3v3_lowspeed (I/O), io2_pdcc_ft_3v3_mediumspeed (I/O), io2_pdcc_ft_3v3_lowspeed_pu (I/O), io2_pdcc_ft_3v3_mediumspeed_pu (I/O), io2_pdcc_ft_3v3_lowspeed_pd (I/O), io2_pdcc_ft_3v3_mediumspeed_pd (I/O), io2_pdcc_ft_1v8_lowspeed (I/O), io2_pdcc_ft_1v8_mediumspeed (I/O), io2_pdcc_ft_1v8_lowspeed_pu (I/O), io2_pdcc_ft_1v8_mediumspeed_pu (I/O), io2_pdcc_ft_1v8_lowspeed_pd (I/O), io2_pdcc_ft_1v8_mediumspeed_pd (I/O), io2_pdcc_ft_1v2_lowspeed (I/O), io2_pdcc_ft_1v2_mediumspeed (I/O), io2_pdcc_ft_1v2_lowspeed_pu (I/O), io2_pdcc_ft_1v2_mediumspeed_pu (I/O), io2_pdcc_ft_1v2_lowspeed_pd (I/O), io2_pdcc_ft_1v2_mediumspeed_pd (I/O), iols8p_sudq_ft_pd_lv (I/O), iols8p_sudq_ft_pu_lv (I/O), iols8p_sudq_ft_lv (I/O), iols8p_sudq_ft_pd (I/O), iols8p_sudq_ft_pu (I/O), iols8p_sudq_ft (I/O), iofs8p_sudq_ft_pd_lv (I/O), iofs8p_sudq_ft_pu_lv (I/O), iofs8p_sudq_ft_lv (I/O), iofs8p_sudq_ft_pd (I/O), iofs8p_sudq_ft_pu (I/O), iofs8p_sudq_ft (I/O), ioms8p_sudq_ft_pd_lv (I/O), ioms8p_sudq_ft_pu_lv (I/O), ioms8p_sudq_ft_lv (I/O), ioms8p_sudq_ft_pd (I/O), ioms8p_sudq_ft_pu (I/O), ioms8p_sudq_ft (I/O), iohs8p_sudq_ft_pd_lv (I/O), iohs8p_sudq_ft_pu_lv (I/O), iohs8p_sudq_ft_lv (I/O), iohs8p_sudq_ft_pd (I/O), iohs8p_sudq_ft_pu (I/O), iohs8p_sudq_ft (I/O), io8prog_1v8_i2c_pd (I/O), io8prog_1v8_i2c_pu (I/O), io8prog_1v8_i2c (I/O), io8prog_3v3_i2c_pd (I/O), io8prog_3v3_i2c_pu (I/O), io8prog_3v3_i2c (I/O), usb_ls_pd (I/O), usb_ls_pu2 (I/O), usb_ls_pu (I/O), usb_fs (I/O), usb_fs_pd (I/O), usb_fs_pu2 (I/O), usb_fs_pu (I/O), ioreset_1v2_pu (I/O_open_drain), ioreset_1v2 (I/O_open_drain), ioreset_1v8_pu (I/O_open_drain), ioreset_1v8 (I/O_open_drain), ioreset_3v3_pu (I/O_open_drain), ioreset_3v3 (I/O_open_drain)
