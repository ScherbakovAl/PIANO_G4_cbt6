| IBIS file stm32g471_473_474_483_484_ufqfpn48.ibs
[IBIS ver]   4.2
[File name]  stm32g471_473_474_483_484_ufqfpn48.ibs
[File Rev]   1.0
[Date]   08-07-2019
[Source]   Data Created at STMicroelectronics
[Notes]   File originated from ELDO simulations.
[Disclaimer] This information is for modeling purpose only and is
   not guaranted. The information is subject to change without
   notice.
[Copyright]  Copyright 2019 STMicroelectronics Inc.
|   Component stm32g471_473_474_483_484_ufqfpn48
[Component] stm32g471_473_474_483_484_ufqfpn48
[Manufacturer] STMicroelectronics
[Package]
| variable   typ   min   max
R_pkg  0  NA  NA
L_pkg  0  NA  NA
C_pkg  0  NA  NA
[Pin]   signal_name   model_name
0 VSS_1 GND
1 VBAT POWER
2 PC13 io8prog2m25m50m120m_sudq_ft
3 PC14-OSC32_IN io8prog2m25m50m120m_sudq_ft
4 PC15-OSC32_OUT io8prog2m25m50m120m_sudq_ft
5 PF0-OSC_IN io8prog2m25m50m120m_sudq_i2c_ft
6 PF1-OSC_OUT io8prog2m25m50m120m_sudq_ft
7 PG10-NRST ioreset_ft_v33
8 PA0 io8prog2m25m50m120m_sudq_ft
9 PA1 io8prog2m25m50m120m_sudq_ft
10 PA2 io8prog2m25m50m120m_sudq_ft
11 PA3 io8prog2m25m50m120m_sudq_ft
12 PA4 io8prog2m25m50m120m_sudq_ft
13 PA5 io8prog2m25m50m120m_sudq_ft
14 PA6 io8prog2m25m50m120m_sudq_ft
15 PA7 io8prog2m25m50m120m_sudq_ft
16 PC4 io8prog2m25m50m120m_sudq_i2c_ft
17 PB0 io8prog2m25m50m120m_sudq_ft
18 PB1 io8prog2m25m50m120m_sudq_ft
19 PB2 io8prog2m25m50m120m_sudq_ft
20 VREF+ POWER
21 VDDA POWER
22 PB10 io8prog2m25m50m120m_sudq_ft
23 VDD_4 POWER
24 PB11 io8prog2m25m50m120m_sudq_ft
25 PB12 io8prog2m25m50m120m_sudq_ft
26 PB13 io8prog2m25m50m120m_sudq_ft
27 PB14 io8prog2m25m50m120m_sudq_ft
28 PB15 io8prog2m25m50m120m_sudq_ft
29 PC6 io8prog2m25m50m120m_sudq_i2c_ft
30 PA8 io8prog2m25m50m120m_sudq_ft
31 PA9 io8prog2m25m50m120m_sudq_i2c_ft
32 PA10 io8prog2m25m50m120m_sudq_i2c_ft
33 PA11 io8usblsfs_otg2
34 PA12 io8usblsfs_otg2
35 VDD_6 POWER
36 PA13 io8prog2m25m50m120m_sudq_i2c_ft
37 PA14 io8prog2m25m50m120m_sudq_i2c_ft
38 PA15 io8prog2m25m50m120m_sudq_i2c_ft
39 PC10 io8prog2m25m50m120m_sudq_ft
40 PC11 io8prog2m25m50m120m_sudq_i2c_ft
41 PB3 io8prog2m25m50m120m_sudq_ft
42 PB4 io6usb_bmc_pd_cc_ft
43 PB5 io8prog2m25m50m120m_sudq_i2c_ft
44 PB6 io6usb_bmc_pd_cc_ft
45 PB7 io8prog2m25m50m120m_sudq_i2c_ft
46 PB8-BOOT0 io8prog2m25m50m120m_sudq_i2c_ft
47 PB9 io8prog2m25m50m120m_sudq_i2c_ft
48 VDD_8 POWER
[Model Selector] io6usb_bmc_pd_cc_ft
usb_bmc_emit_pdccpd  "BMC PD emitter  + PD"
usb_bmc_emit_pdcc3a0  "BMC PD emitter  + 3rd PU"
usb_bmc_emit_pdcc1a5  "BMC PD emitter  + 2nd PU"
usb_bmc_emit_pdccusb  "BMC PD emitter  + 1st PU"
usb_bmc_emit  "BMC PD emitter "
io2_pdcc_ft_3v3_lowspeed  "GPIO-3.3V range - low speed"
io2_pdcc_ft_3v3_mediumspeed  "GPIO-3.3V range - medium speed"
io2_pdcc_ft_3v3_lowspeed_pu  "GPIO-3.3V range - low speed - pull up"
io2_pdcc_ft_3v3_mediumspeed_pu  "GPIO-3.3V range - medium speed - pull up"
io2_pdcc_ft_3v3_lowspeed_pd  "GPIO-3.3V range - low speed - pull down"
io2_pdcc_ft_3v3_mediumspeed_pd  "GPIO-3.3V range - medium speed - pull down"
io2_pdcc_ft_1v8_lowspeed  "GPIO-1.8V range - low speed"
io2_pdcc_ft_1v8_mediumspeed  "GPIO-1.8V range - medium speed"
io2_pdcc_ft_1v8_lowspeed_pu  "GPIO-1.8V range - low speed - pull up"
io2_pdcc_ft_1v8_mediumspeed_pu  "GPIO-1.8V range - medium speed - pull up"
io2_pdcc_ft_1v8_lowspeed_pd  "GPIO-1.8V range - low speed - pull down"
io2_pdcc_ft_1v8_mediumspeed_pd  "GPIO-1.8V range - medium speed - pull down"
io2_pdcc_ft_1v2_lowspeed  "GPIO-1.2V range - low speed"
io2_pdcc_ft_1v2_mediumspeed  "GPIO-1.2V range - medium speed"
io2_pdcc_ft_1v2_lowspeed_pu  "GPIO-1.2V range - low speed - pull up"
io2_pdcc_ft_1v2_mediumspeed_pu  "GPIO-1.2V range - medium speed - pull up"
io2_pdcc_ft_1v2_lowspeed_pd  "GPIO-1.2V range - low speed - pull down"
io2_pdcc_ft_1v2_mediumspeed_pd  "GPIO-1.2V range - medium speed - pull down"
[Model Selector] io8prog2m25m50m120m_sudq_ft
iols8p_sudq_ft_pd_lv  "IO low speed, PD=40kOhm - 1P8V"
iols8p_sudq_ft_pu_lv  "IO low speed, PU=40kOhm - 1P8V"
iols8p_sudq_ft_lv  "IO low speed - 1P8V"
iols8p_sudq_ft_pd  "IO low speed, PD=40kOhm - 3P3V"
iols8p_sudq_ft_pu  "IO low speed, PU=40kOhm - 3P3V"
iols8p_sudq_ft  "IO low speed - 3P3V"
iofs8p_sudq_ft_pd_lv  "IO full speed, PD=40kOhm - 1P8V"
iofs8p_sudq_ft_pu_lv  "IO full speed, PU=40kOhm - 1P8V"
iofs8p_sudq_ft_lv  "IO full speed - 1P8V"
iofs8p_sudq_ft_pd  "IO full speed, PD=40kOhm - 3P3V"
iofs8p_sudq_ft_pu  "IO full speed, PU=40kOhm - 3P3V"
iofs8p_sudq_ft  "IO full speed - 3P3V"
ioms8p_sudq_ft_pd_lv  "IO medium speed, PD=40kOhm - 1P8V"
ioms8p_sudq_ft_pu_lv  "IO medium speed, PU=40kOhm - 1P8V"
ioms8p_sudq_ft_lv  "IO medium speed - 1P8V"
ioms8p_sudq_ft_pd  "IO medium speed, PD=40kOhm - 3P3V"
ioms8p_sudq_ft_pu  "IO medium speed, PU=40kOhm - 3P3V"
ioms8p_sudq_ft  "IO medium speed - 3P3V"
iohs8p_sudq_ft_pd_lv  "IO high speed, PD=40kOhm - 1P8V"
iohs8p_sudq_ft_pu_lv  "IO high speed, PU=40kOhm - 1P8V"
iohs8p_sudq_ft_lv  "IO high speed - 1P8V"
iohs8p_sudq_ft_pd  "IO high speed, PD=40kOhm - 3P3V"
iohs8p_sudq_ft_pu  "IO high speed, PU=40kOhm - 3P3V"
iohs8p_sudq_ft  "IO high speed - 3P3V"
[Model Selector] io8prog2m25m50m120m_sudq_i2c_ft
io8prog_1v8_i2c_pd  "5V Tol GPIO 1.8V range i2c functionality with pull down"
io8prog_1v8_i2c_pu  "5V Tol GPIO 1.8V range i2c functionality with pull up"
io8prog_1v8_i2c  "5V Tol GPIO 1.8V range i2c functionality"
io8prog_3v3_i2c_pd  "5V Tol GPIO 3.3V range i2c functionality with pull down"
io8prog_3v3_i2c_pu  "5V Tol GPIO 3.3V range i2c functionality with pull up"
io8prog_3v3_i2c  "5V Tol GPIO 3.3V range i2c functionality"
iols8p_sudq_ft_pd_lv  "IO low speed, PD=40kOhm - 1P8V"
iols8p_sudq_ft_pu_lv  "IO low speed, PU=40kOhm - 1P8V"
iols8p_sudq_ft_lv  "IO low speed - 1P8V"
iols8p_sudq_ft_pd  "IO low speed, PD=40kOhm - 3P3V"
iols8p_sudq_ft_pu  "IO low speed, PU=40kOhm - 3P3V"
iols8p_sudq_ft  "IO low speed - 3P3V"
iofs8p_sudq_ft_pd_lv  "IO full speed, PD=40kOhm - 1P8V"
iofs8p_sudq_ft_pu_lv  "IO full speed, PU=40kOhm - 1P8V"
iofs8p_sudq_ft_lv  "IO full speed - 1P8V"
iofs8p_sudq_ft_pd  "IO full speed, PD=40kOhm - 3P3V"
iofs8p_sudq_ft_pu  "IO full speed, PU=40kOhm - 3P3V"
iofs8p_sudq_ft  "IO full speed - 3P3V"
ioms8p_sudq_ft_pd_lv  "IO medium speed, PD=40kOhm - 1P8V"
ioms8p_sudq_ft_pu_lv  "IO medium speed, PU=40kOhm - 1P8V"
ioms8p_sudq_ft_lv  "IO medium speed - 1P8V"
ioms8p_sudq_ft_pd  "IO medium speed, PD=40kOhm - 3P3V"
ioms8p_sudq_ft_pu  "IO medium speed, PU=40kOhm - 3P3V"
ioms8p_sudq_ft  "IO medium speed - 3P3V"
iohs8p_sudq_ft_pd_lv  "IO high speed, PD=40kOhm - 1P8V"
iohs8p_sudq_ft_pu_lv  "IO high speed, PU=40kOhm - 1P8V"
iohs8p_sudq_ft_lv  "IO high speed - 1P8V"
iohs8p_sudq_ft_pd  "IO high speed, PD=40kOhm - 3P3V"
iohs8p_sudq_ft_pu  "IO high speed, PU=40kOhm - 3P3V"
iohs8p_sudq_ft  "IO high speed - 3P3V"
[Model Selector] io8usblsfs_otg2
usb_ls_pd  "USB Low Speed mode - Pull Down"
usb_ls_pu2  "USB Low Speed mode - Pull up 2"
usb_ls_pu  "USB Low Speed mode - Pull up"
usb_fs  "USB Low Speed mode"
usb_fs_pd  "USB Full Speed mode - Pull Down"
usb_fs_pu2  "USB Full Speed mode - Pull up 2"
usb_fs_pu  "USB Full Speed mode - Pull up"
[Model Selector] ioreset_ft_v33
ioreset_1v2_pu  "RESET 1.2V range with PU"
ioreset_1v2  "RESET 1.2V range"
ioreset_1v8_pu  "RESET 1.8V range with PU"
ioreset_1v8  "RESET 1.8V range"
ioreset_3v3_pu  "RESET 3.3V range with PU"
ioreset_3v3  "RESET 3.3V range"
| Models and submodels in the file (66): usb_bmc_emit_pdccpd (I/O), usb_bmc_emit_pdcc3a0 (I/O), usb_bmc_emit_pdcc1a5 (I/O), usb_bmc_emit_pdccusb (I/O), usb_bmc_emit (I/O), io2_pdcc_ft_3v3_lowspeed (I/O), io2_pdcc_ft_3v3_mediumspeed (I/O), io2_pdcc_ft_3v3_lowspeed_pu (I/O), io2_pdcc_ft_3v3_mediumspeed_pu (I/O), io2_pdcc_ft_3v3_lowspeed_pd (I/O), io2_pdcc_ft_3v3_mediumspeed_pd (I/O), io2_pdcc_ft_1v8_lowspeed (I/O), io2_pdcc_ft_1v8_mediumspeed (I/O), io2_pdcc_ft_1v8_lowspeed_pu (I/O), io2_pdcc_ft_1v8_mediumspeed_pu (I/O), io2_pdcc_ft_1v8_lowspeed_pd (I/O), io2_pdcc_ft_1v8_mediumspeed_pd (I/O), io2_pdcc_ft_1v2_lowspeed (I/O), io2_pdcc_ft_1v2_mediumspeed (I/O), io2_pdcc_ft_1v2_lowspeed_pu (I/O), io2_pdcc_ft_1v2_mediumspeed_pu (I/O), io2_pdcc_ft_1v2_lowspeed_pd (I/O), io2_pdcc_ft_1v2_mediumspeed_pd (I/O), iols8p_sudq_ft_pd_lv (I/O), iols8p_sudq_ft_pu_lv (I/O), iols8p_sudq_ft_lv (I/O), iols8p_sudq_ft_pd (I/O), iols8p_sudq_ft_pu (I/O), iols8p_sudq_ft (I/O), iofs8p_sudq_ft_pd_lv (I/O), iofs8p_sudq_ft_pu_lv (I/O), iofs8p_sudq_ft_lv (I/O), iofs8p_sudq_ft_pd (I/O), iofs8p_sudq_ft_pu (I/O), iofs8p_sudq_ft (I/O), ioms8p_sudq_ft_pd_lv (I/O), ioms8p_sudq_ft_pu_lv (I/O), ioms8p_sudq_ft_lv (I/O), ioms8p_sudq_ft_pd (I/O), ioms8p_sudq_ft_pu (I/O), ioms8p_sudq_ft (I/O), iohs8p_sudq_ft_pd_lv (I/O), iohs8p_sudq_ft_pu_lv (I/O), iohs8p_sudq_ft_lv (I/O), iohs8p_sudq_ft_pd (I/O), iohs8p_sudq_ft_pu (I/O), iohs8p_sudq_ft (I/O), io8prog_1v8_i2c_pd (I/O), io8prog_1v8_i2c_pu (I/O), io8prog_1v8_i2c (I/O), io8prog_3v3_i2c_pd (I/O), io8prog_3v3_i2c_pu (I/O), io8prog_3v3_i2c (I/O), usb_ls_pd (I/O), usb_ls_pu2 (I/O), usb_ls_pu (I/O), usb_fs (I/O), usb_fs_pd (I/O), usb_fs_pu2 (I/O), usb_fs_pu (I/O), ioreset_1v2_pu (I/O_open_drain), ioreset_1v2 (I/O_open_drain), ioreset_1v8_pu (I/O_open_drain), ioreset_1v8 (I/O_open_drain), ioreset_3v3_pu (I/O_open_drain), ioreset_3v3 (I/O_open_drain)
