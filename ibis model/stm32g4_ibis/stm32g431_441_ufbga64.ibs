| IBIS file stm32g431_441_ufbga64.ibs
[IBIS ver]   4.2
[File name]  stm32g431_441_ufbga64.ibs
[File Rev]   1.0
[Date]   05-07-2019
[Source]   Data Created at STMicroelectronics
[Notes]   File originated from ELDO simulations.
[Disclaimer] This information is for modeling purpose only and is
   not guaranted. The information is subject to change without
   notice.
[Copyright]  Copyright 2019 STMicroelectronics Inc.
|   Component stm32g431_441_ufbga64
[Component] stm32g431_441_ufbga64
[Manufacturer] STMicroelectronics
[Package]
| variable   typ   min   max
R_pkg  1.31E-01  9.49E-02  2.35E-01
L_pkg  8.82E-10  6.02E-10  1.62E-09
C_pkg  3.79E-13  2.31E-13  6.29E-13
[Pin]   signal_name   model_name
A1  VDD  power
A2  PB9  io8prog2m25m50m120m_sudq_i2c_ft
A3  PB7  io8prog2m25m50m120m_sudq_i2c_ft
A4  PB6  io6usb_bmc_pd_cc_ft
A5  PB3  io8prog2m25m50m120m_sudq_ft
A6  PC12  io8prog2m25m50m120m_sudq_ft
A7  PA15  io8prog2m25m50m120m_sudq_i2c_ft
A8  VDD  power
B1  PC13  io8prog2m25m50m120m_sudq_ft
B2  VSS  gnd
B3  PB8  io8prog2m25m50m120m_sudq_i2c_ft
B4  PB5  io8prog2m25m50m120m_sudq_i2c_ft
B5  PD2  io8prog2m25m50m120m_sudq_ft
B6  PC11  io8prog2m25m50m120m_sudq_i2c_ft
B7  VSS  gnd
B8  PA12  io8usblsfs_otg2
C1  PC14  io8prog2m25m50m120m_sudq_ft
C2  VBAT  power
C3  PC1  io8prog2m25m50m120m_sudq_ft
C4  PB4  io6usb_bmc_pd_cc_ft
C5  PC10  io8prog2m25m50m120m_sudq_ft
C6  PA14  io8prog2m25m50m120m_sudq_i2c_ft
C7  PA13  io8prog2m25m50m120m_sudq_i2c_ft
C8  PA11  io8usblsfs_otg2
D1  PC15  io8prog2m25m50m120m_sudq_ft
D2  PG10  ioreset_ft_v33
D3  PC2  io8prog2m25m50m120m_sudq_ft
D4  PA4  io8prog2m25m50m120m_sudq_ft
D5  PC4  io8prog2m25m50m120m_sudq_i2c_ft
D6  PA10  io8prog2m25m50m120m_sudq_ft
D7  PA9  io8prog2m25m50m120m_sudq_ft
D8  PC9  io8prog2m25m50m120m_sudq_i2c_ft
E1  PF0  io8prog2m25m50m120m_sudq_i2c_ft
E2  PC0  io8prog2m25m50m120m_sudq_ft
E3  PA1  io8prog2m25m50m120m_sudq_ft
E4  PA5  io8prog2m25m50m120m_sudq_ft
E5  PB0  io8prog2m25m50m120m_sudq_ft
E6  PA8  io8prog2m25m50m120m_sudq_i2c_ft
E7  PC7  io8prog2m25m50m120m_sudq_i2c_ft
E8  PC6  io8prog2m25m50m120m_sudq_i2c_ft
F1  PF1  io8prog2m25m50m120m_sudq_ft
F2  PA0  io8prog2m25m50m120m_sudq_ft
F3  PA2  io8prog2m25m50m120m_sudq_ft
F4  PC5  io8prog2m25m50m120m_sudq_ft
F5  PB1  io8prog2m25m50m120m_sudq_ft
F6  PC8  io8prog2m25m50m120m_sudq_i2c_ft
F7  PB15  io8prog2m25m50m120m_sudq_ft
F8  PB14  io8prog2m25m50m120m_sudq_ft
G1  PC3  io8prog2m25m50m120m_sudq_ft
G2  VSS  gnd
G3  PA6  io8prog2m25m50m120m_sudq_ft
G4  VSSA  nc
G5  VREFP  nc
G6  PB13  io8prog2m25m50m120m_sudq_ft
G7  VSS  gnd
G8  PB12  io8prog2m25m50m120m_sudq_ft
H1  VDD  power
H2  PA3  io8prog2m25m50m120m_sudq_ft
H3  PA7  io8prog2m25m50m120m_sudq_ft
H4  PB2  io8prog2m25m50m120m_sudq_ft
H5  VDDA  nc
H6  PB10  io8prog2m25m50m120m_sudq_ft
H7  PB11  io8prog2m25m50m120m_sudq_ft
H8  VDD  power
[Package Model]   stm32g431_441_ufbga_64
[Pin Mapping]   pulldown_ref   pullup_ref   | Comment
A1  nc  vddio
A2  gndio  vddio
A3  gndio  vddio
A4  gndio  vddio
A5  gndio  vddio
A6  gndio  vddio
A7  gndio  vddio
A8  nc  vddio
B1  gndio  vddio  | Depending on IO usage
| B1  gndio  vswitch  | Depending on IO usage
B2  gndio  nc
B3  gndio  vddio
B4  gndio  vddio
B5  gndio  vddio
B6  gndio  vddio
B7  gndio  nc
B8  gndio  vddio
C1  gndio  vddio  | Depending on IO usage
| C1  gndio  vswitch  | Depending on IO usage
C2  nc  vswitch
C3  gndio  vddio
C4  gndio  vddio
C5  gndio  vddio
C6  gndio  vddio
C7  gndio  vddio
C8  gndio  vddio
D1  gndio  vddio  | Depending on IO usage
| D1  gndio  vswitch  | Depending on IO usage
D2  gndio  vddio
D3  gndio  vddio
D4  gndio  vddio
D5  gndio  vddio
D6  gndio  vddio
D7  gndio  vddio
D8  gndio  vddio
E1  gndio  vddio
E2  gndio  vddio
E3  gndio  vddio
E4  gndio  vddio
E5  gndio  vddio
E6  gndio  vddio
E7  gndio  vddio
E8  gndio  vddio
F1  gndio  vddio
F2  gndio  vddio
F3  gndio  vddio
F4  gndio  vddio
F5  gndio  vddio
F6  gndio  vddio
F7  gndio  vddio
F8  gndio  vddio
G1  gndio  vddio
G2  gndio  nc
G3  gndio  vddio
G4  nc  nc
G5  nc  nc
G6  gndio  vddio
G7  gndio  nc
G8  gndio  vddio
H1  nc  vddio
H2  gndio  vddio
H3  gndio  vddio
H4  gndio  vddio
H5  nc  nc
H6  gndio  vddio
H7  gndio  vddio
H8  nc  vddio
[Model Selector] io6usb_bmc_pd_cc_ft
usb_bmc_emit_pdccpd  "BMC PD emitter  + PD"
usb_bmc_emit_pdcc3a0  "BMC PD emitter  + 3rd PU"
usb_bmc_emit_pdcc1a5  "BMC PD emitter  + 2nd PU"
usb_bmc_emit_pdccusb  "BMC PD emitter  + 1st PU"
usb_bmc_emit  "BMC PD emitter "
io2_pdcc_ft_3v3_lowspeed  "GPIO-3.3V range - low speed"
io2_pdcc_ft_3v3_mediumspeed  "GPIO-3.3V range - medium speed"
io2_pdcc_ft_3v3_lowspeed_pu  "GPIO-3.3V range - low speed - pull up"
io2_pdcc_ft_3v3_mediumspeed_pu  "GPIO-3.3V range - medium speed - pull up"
io2_pdcc_ft_3v3_lowspeed_pd  "GPIO-3.3V range - low speed - pull down"
io2_pdcc_ft_3v3_mediumspeed_pd  "GPIO-3.3V range - medium speed - pull down"
io2_pdcc_ft_1v8_lowspeed  "GPIO-1.8V range - low speed"
io2_pdcc_ft_1v8_mediumspeed  "GPIO-1.8V range - medium speed"
io2_pdcc_ft_1v8_lowspeed_pu  "GPIO-1.8V range - low speed - pull up"
io2_pdcc_ft_1v8_mediumspeed_pu  "GPIO-1.8V range - medium speed - pull up"
io2_pdcc_ft_1v8_lowspeed_pd  "GPIO-1.8V range - low speed - pull down"
io2_pdcc_ft_1v8_mediumspeed_pd  "GPIO-1.8V range - medium speed - pull down"
io2_pdcc_ft_1v2_lowspeed  "GPIO-1.2V range - low speed"
io2_pdcc_ft_1v2_mediumspeed  "GPIO-1.2V range - medium speed"
io2_pdcc_ft_1v2_lowspeed_pu  "GPIO-1.2V range - low speed - pull up"
io2_pdcc_ft_1v2_mediumspeed_pu  "GPIO-1.2V range - medium speed - pull up"
io2_pdcc_ft_1v2_lowspeed_pd  "GPIO-1.2V range - low speed - pull down"
io2_pdcc_ft_1v2_mediumspeed_pd  "GPIO-1.2V range - medium speed - pull down"
[Model Selector] io8prog2m25m50m120m_sudq_ft
iols8p_sudq_ft_pd_lv  "IO low speed, PD=40kOhm - 1P8V"
iols8p_sudq_ft_pu_lv  "IO low speed, PU=40kOhm - 1P8V"
iols8p_sudq_ft_lv  "IO low speed - 1P8V"
iols8p_sudq_ft_pd  "IO low speed, PD=40kOhm - 3P3V"
iols8p_sudq_ft_pu  "IO low speed, PU=40kOhm - 3P3V"
iols8p_sudq_ft  "IO low speed - 3P3V"
iofs8p_sudq_ft_pd_lv  "IO full speed, PD=40kOhm - 1P8V"
iofs8p_sudq_ft_pu_lv  "IO full speed, PU=40kOhm - 1P8V"
iofs8p_sudq_ft_lv  "IO full speed - 1P8V"
iofs8p_sudq_ft_pd  "IO full speed, PD=40kOhm - 3P3V"
iofs8p_sudq_ft_pu  "IO full speed, PU=40kOhm - 3P3V"
iofs8p_sudq_ft  "IO full speed - 3P3V"
ioms8p_sudq_ft_pd_lv  "IO medium speed, PD=40kOhm - 1P8V"
ioms8p_sudq_ft_pu_lv  "IO medium speed, PU=40kOhm - 1P8V"
ioms8p_sudq_ft_lv  "IO medium speed - 1P8V"
ioms8p_sudq_ft_pd  "IO medium speed, PD=40kOhm - 3P3V"
ioms8p_sudq_ft_pu  "IO medium speed, PU=40kOhm - 3P3V"
ioms8p_sudq_ft  "IO medium speed - 3P3V"
iohs8p_sudq_ft_pd_lv  "IO high speed, PD=40kOhm - 1P8V"
iohs8p_sudq_ft_pu_lv  "IO high speed, PU=40kOhm - 1P8V"
iohs8p_sudq_ft_lv  "IO high speed - 1P8V"
iohs8p_sudq_ft_pd  "IO high speed, PD=40kOhm - 3P3V"
iohs8p_sudq_ft_pu  "IO high speed, PU=40kOhm - 3P3V"
iohs8p_sudq_ft  "IO high speed - 3P3V"
[Model Selector] io8prog2m25m50m120m_sudq_i2c_ft
io8prog_1v8_i2c_pd  "5V Tol GPIO 1.8V range i2c functionality with pull down"
io8prog_1v8_i2c_pu  "5V Tol GPIO 1.8V range i2c functionality with pull up"
io8prog_1v8_i2c  "5V Tol GPIO 1.8V range i2c functionality"
io8prog_3v3_i2c_pd  "5V Tol GPIO 3.3V range i2c functionality with pull down"
io8prog_3v3_i2c_pu  "5V Tol GPIO 3.3V range i2c functionality with pull up"
io8prog_3v3_i2c  "5V Tol GPIO 3.3V range i2c functionality"
iols8p_sudq_ft_pd_lv  "IO low speed, PD=40kOhm - 1P8V"
iols8p_sudq_ft_pu_lv  "IO low speed, PU=40kOhm - 1P8V"
iols8p_sudq_ft_lv  "IO low speed - 1P8V"
iols8p_sudq_ft_pd  "IO low speed, PD=40kOhm - 3P3V"
iols8p_sudq_ft_pu  "IO low speed, PU=40kOhm - 3P3V"
iols8p_sudq_ft  "IO low speed - 3P3V"
iofs8p_sudq_ft_pd_lv  "IO full speed, PD=40kOhm - 1P8V"
iofs8p_sudq_ft_pu_lv  "IO full speed, PU=40kOhm - 1P8V"
iofs8p_sudq_ft_lv  "IO full speed - 1P8V"
iofs8p_sudq_ft_pd  "IO full speed, PD=40kOhm - 3P3V"
iofs8p_sudq_ft_pu  "IO full speed, PU=40kOhm - 3P3V"
iofs8p_sudq_ft  "IO full speed - 3P3V"
ioms8p_sudq_ft_pd_lv  "IO medium speed, PD=40kOhm - 1P8V"
ioms8p_sudq_ft_pu_lv  "IO medium speed, PU=40kOhm - 1P8V"
ioms8p_sudq_ft_lv  "IO medium speed - 1P8V"
ioms8p_sudq_ft_pd  "IO medium speed, PD=40kOhm - 3P3V"
ioms8p_sudq_ft_pu  "IO medium speed, PU=40kOhm - 3P3V"
ioms8p_sudq_ft  "IO medium speed - 3P3V"
iohs8p_sudq_ft_pd_lv  "IO high speed, PD=40kOhm - 1P8V"
iohs8p_sudq_ft_pu_lv  "IO high speed, PU=40kOhm - 1P8V"
iohs8p_sudq_ft_lv  "IO high speed - 1P8V"
iohs8p_sudq_ft_pd  "IO high speed, PD=40kOhm - 3P3V"
iohs8p_sudq_ft_pu  "IO high speed, PU=40kOhm - 3P3V"
iohs8p_sudq_ft  "IO high speed - 3P3V"
[Model Selector] io8usblsfs_otg2
usb_ls_pd  "USB Low Speed mode - Pull Down"
usb_ls_pu2  "USB Low Speed mode - Pull up 2"
usb_ls_pu  "USB Low Speed mode - Pull up"
usb_fs  "USB Low Speed mode"
usb_fs_pd  "USB Full Speed mode - Pull Down"
usb_fs_pu2  "USB Full Speed mode - Pull up 2"
usb_fs_pu  "USB Full Speed mode - Pull up"
[Model Selector] ioreset_ft_v33
ioreset_1v2_pu  "RESET 1.2V range with PU"
ioreset_1v2  "RESET 1.2V range"
ioreset_1v8_pu  "RESET 1.8V range with PU"
ioreset_1v8  "RESET 1.8V range"
ioreset_3v3_pu  "RESET 3.3V range with PU"
ioreset_3v3  "RESET 3.3V range"
[Define Package Model]  stm32g431_441_ufbga_64
[Manufacturer]  Unknown
[OEM]  Unknown
[Description]  None
[Number Of Pins]  58
[Pin Numbers]
| Pin Num   Terminal Name
F2 | PA0
E3 | PA1
F3 | PA2
H2 | PA3
D4 | PA4
E4 | PA5
G3 | PA6
H3 | PA7
E6 | PA8
D7 | PA9
D6 | PA10
C8 | PA11
B8 | PA12
C7 | PA13
C6 | PA14
A7 | PA15
E5 | PB0
F5 | PB1
H4 | PB2
A5 | PB3
C4 | PB4
B4 | PB5
A4 | PB6
A3 | PB7
B3 | PB8
A2 | PB9
H6 | PB10
H7 | PB11
G8 | PB12
G6 | PB13
F8 | PB14
F7 | PB15
E2 | PC0
C3 | PC1
D3 | PC2
G1 | PC3
D5 | PC4
F4 | PC5
E8 | PC6
E7 | PC7
F6 | PC8
D8 | PC9
C5 | PC10
B6 | PC11
A6 | PC12
B1 | PC13
C1 | PC14
D1 | PC15
B5 | PD2
E1 | PF0
F1 | PF1
D2 | PG10
C2 | VBAT
A1 | VDD
H5 | VDDA
G5 | VREFP
B2 | VSS
G4 | VSSA
[Model Data]
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[End Model Data]
[End Package Model]
| Models and submodels in the file (66): usb_bmc_emit_pdccpd (I/O), usb_bmc_emit_pdcc3a0 (I/O), usb_bmc_emit_pdcc1a5 (I/O), usb_bmc_emit_pdccusb (I/O), usb_bmc_emit (I/O), io2_pdcc_ft_3v3_lowspeed (I/O), io2_pdcc_ft_3v3_mediumspeed (I/O), io2_pdcc_ft_3v3_lowspeed_pu (I/O), io2_pdcc_ft_3v3_mediumspeed_pu (I/O), io2_pdcc_ft_3v3_lowspeed_pd (I/O), io2_pdcc_ft_3v3_mediumspeed_pd (I/O), io2_pdcc_ft_1v8_lowspeed (I/O), io2_pdcc_ft_1v8_mediumspeed (I/O), io2_pdcc_ft_1v8_lowspeed_pu (I/O), io2_pdcc_ft_1v8_mediumspeed_pu (I/O), io2_pdcc_ft_1v8_lowspeed_pd (I/O), io2_pdcc_ft_1v8_mediumspeed_pd (I/O), io2_pdcc_ft_1v2_lowspeed (I/O), io2_pdcc_ft_1v2_mediumspeed (I/O), io2_pdcc_ft_1v2_lowspeed_pu (I/O), io2_pdcc_ft_1v2_mediumspeed_pu (I/O), io2_pdcc_ft_1v2_lowspeed_pd (I/O), io2_pdcc_ft_1v2_mediumspeed_pd (I/O), iols8p_sudq_ft_pd_lv (I/O), iols8p_sudq_ft_pu_lv (I/O), iols8p_sudq_ft_lv (I/O), iols8p_sudq_ft_pd (I/O), iols8p_sudq_ft_pu (I/O), iols8p_sudq_ft (I/O), iofs8p_sudq_ft_pd_lv (I/O), iofs8p_sudq_ft_pu_lv (I/O), iofs8p_sudq_ft_lv (I/O), iofs8p_sudq_ft_pd (I/O), iofs8p_sudq_ft_pu (I/O), iofs8p_sudq_ft (I/O), ioms8p_sudq_ft_pd_lv (I/O), ioms8p_sudq_ft_pu_lv (I/O), ioms8p_sudq_ft_lv (I/O), ioms8p_sudq_ft_pd (I/O), ioms8p_sudq_ft_pu (I/O), ioms8p_sudq_ft (I/O), iohs8p_sudq_ft_pd_lv (I/O), iohs8p_sudq_ft_pu_lv (I/O), iohs8p_sudq_ft_lv (I/O), iohs8p_sudq_ft_pd (I/O), iohs8p_sudq_ft_pu (I/O), iohs8p_sudq_ft (I/O), io8prog_1v8_i2c_pd (I/O), io8prog_1v8_i2c_pu (I/O), io8prog_1v8_i2c (I/O), io8prog_3v3_i2c_pd (I/O), io8prog_3v3_i2c_pu (I/O), io8prog_3v3_i2c (I/O), usb_ls_pd (I/O), usb_ls_pu2 (I/O), usb_ls_pu (I/O), usb_fs (I/O), usb_fs_pd (I/O), usb_fs_pu2 (I/O), usb_fs_pu (I/O), ioreset_1v2_pu (I/O_open_drain), ioreset_1v2 (I/O_open_drain), ioreset_1v8_pu (I/O_open_drain), ioreset_1v8 (I/O_open_drain), ioreset_3v3_pu (I/O_open_drain), ioreset_3v3 (I/O_open_drain)
