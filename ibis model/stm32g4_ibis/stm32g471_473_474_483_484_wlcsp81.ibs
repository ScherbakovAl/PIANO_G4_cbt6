| IBIS file stm32g471_473_474_483_484_wlcsp81.ibs
[IBIS ver]   4.2
[File name]  stm32g471_473_474_483_484_wlcsp81.ibs
[File Rev]   1.0
[Date]   08-07-2019
[Source]   Data Created at STMicroelectronics
[Notes]   File originated from ELDO simulations.
[Disclaimer] This information is for modeling purpose only and is
   not guaranted. The information is subject to change without
   notice.
[Copyright]  Copyright 2019 STMicroelectronics Inc.
|   Component stm32g471_473_474_483_484_wlcsp81
[Component] stm32g471_473_474_483_484_wlcsp81
[Manufacturer] STMicroelectronics
[Package]
| variable   typ   min   max
R_pkg  0  NA  NA
L_pkg  0  NA  NA
C_pkg  0  NA  NA
[Pin]   signal_name   model_name
A1  VDD  power
A2  PA15  io8prog2m25m50m120m_sudq_i2c_ft
A3  PC12  io8prog2m25m50m120m_sudq_ft
A4  PD1  io8prog2m25m50m120m_sudq_ft
A5  PB3  io8prog2m25m50m120m_sudq_ft
A6  PB5  io8prog2m25m50m120m_sudq_i2c_ft
A7  PB9  io8prog2m25m50m120m_sudq_i2c_ft
A8  VSS  gnd
A9  VDD  power
B1  VSS  gnd
B2  PA13  io8prog2m25m50m120m_sudq_i2c_ft
B3  PC10  io8prog2m25m50m120m_sudq_ft
B4  PD0  io8prog2m25m50m120m_sudq_ft
B5  PD2  io8prog2m25m50m120m_sudq_ft
B6  PB6  io6usb_bmc_pd_cc_ft
B7  PB8-BOOT0  io8prog2m25m50m120m_sudq_i2c_ft
B8  PC13  io8prog2m25m50m120m_sudq_ft
B9  VBAT  power
C1  PA12  io8usblsfs_otg2
C2  PA11  io8usblsfs_otg2
C3  PA14  io8prog2m25m50m120m_sudq_i2c_ft
C4  PC11  io8prog2m25m50m120m_sudq_i2c_ft
C5  PC8  io8prog2m25m50m120m_sudq_i2c_ft
C6  PB4  io6usb_bmc_pd_cc_ft
C7  PB7  io8prog2m25m50m120m_sudq_i2c_ft
C8  PC1  io8prog2m25m50m120m_sudq_ft
C9  PC14-OSC32_IN  io8prog2m25m50m120m_sudq_ft
D1  PA8  io8prog2m25m50m120m_sudq_ft
D2  PC9  io8prog2m25m50m120m_sudq_i2c_ft
D3  PA10  io8prog2m25m50m120m_sudq_i2c_ft
D4  PA9  io8prog2m25m50m120m_sudq_i2c_ft
D5  PC7  io8prog2m25m50m120m_sudq_i2c_ft
D6  PA4  io8prog2m25m50m120m_sudq_ft
D7  PA0  io8prog2m25m50m120m_sudq_ft
D8  PG10-NRST  ioreset_ft_v33
D9  PC15-OSC32_OUT  io8prog2m25m50m120m_sudq_ft
E1  VDD  power
E2  PD11  io8prog2m25m50m120m_sudq_ft
E3  PC6  io8prog2m25m50m120m_sudq_i2c_ft
E4  PB15  io8prog2m25m50m120m_sudq_ft
E5  PE12  io8prog2m25m50m120m_sudq_ft
E6  PC4  io8prog2m25m50m120m_sudq_i2c_ft
E7  PA1  io8prog2m25m50m120m_sudq_ft
E8  PC0  io8prog2m25m50m120m_sudq_ft
E9  PF0-OSC_IN  io8prog2m25m50m120m_sudq_i2c_ft
F1  VSS  gnd
F2  PD10  io8prog2m25m50m120m_sudq_ft
F3  PD9  io8prog2m25m50m120m_sudq_ft
F4  PE15  io8prog2m25m50m120m_sudq_ft
F5  PE9  io8prog2m25m50m120m_sudq_ft
F6  PB0  io8prog2m25m50m120m_sudq_ft
F7  PA5  io8prog2m25m50m120m_sudq_ft
F8  PC2  io8prog2m25m50m120m_sudq_ft
F9  PF1-OSC_OUT  io8prog2m25m50m120m_sudq_ft
G1  PD8  io8prog2m25m50m120m_sudq_ft
G2  PB14  io8prog2m25m50m120m_sudq_ft
G3  PB12  io8prog2m25m50m120m_sudq_ft
G4  PE13  io8prog2m25m50m120m_sudq_ft
G5  PE8  io8prog2m25m50m120m_sudq_ft
G6  PB1  io8prog2m25m50m120m_sudq_ft
G7  PA6  io8prog2m25m50m120m_sudq_ft
G8  PA2  io8prog2m25m50m120m_sudq_ft
G9  PC3  io8prog2m25m50m120m_sudq_ft
H1  PB13  io8prog2m25m50m120m_sudq_ft
H2  PB11  io8prog2m25m50m120m_sudq_ft
H3  PB10  io8prog2m25m50m120m_sudq_ft
H4  PE11  io8prog2m25m50m120m_sudq_ft
H5  PE7  io8prog2m25m50m120m_sudq_ft
H6  VSSA  nc
H7  PC5  io8prog2m25m50m120m_sudq_ft
H8  PA3  io8prog2m25m50m120m_sudq_ft
H9  VSS  gnd
J1  VDD  power
J2  VSS  gnd
J3  PE14  io8prog2m25m50m120m_sudq_ft
J4  PE10  io8prog2m25m50m120m_sudq_ft
J5  VDDA  nc
J6  VREF+  nc
J7  PB2  io8prog2m25m50m120m_sudq_ft
J8  PA7  io8prog2m25m50m120m_sudq_ft
J9  VDD  power
[Package Model]   stm32g471_473_474_483_484_wlcsp_81
[Pin Mapping]   pulldown_ref   pullup_ref   | Comment
A1  nc  vddio
A2  gndio  vddio
A3  gndio  vddio
A4  gndio  vddio
A5  gndio  vddio
A6  gndio  vddio
A7  gndio  vddio
A8  gndio  nc
A9  nc  vddio
B1  gndio  nc
B2  gndio  vddio
B3  gndio  vddio
B4  gndio  vddio
B5  gndio  vddio
B6  gndio  vddio
B7  gndio  vddio
B8  gndio  vddio  | Depending on IO usage
| B8  gndio  vswitch  | Depending on IO usage
B9  nc  vswitch
C1  gndio  vddio
C2  gndio  vddio
C3  gndio  vddio
C4  gndio  vddio
C5  gndio  vddio
C6  gndio  vddio
C7  gndio  vddio
C8  gndio  vddio
C9  gndio  vddio  | Depending on IO usage
| C9  gndio  vswitch  | Depending on IO usage
D1  gndio  vddio
D2  gndio  vddio
D3  gndio  vddio
D4  gndio  vddio
D5  gndio  vddio
D6  gndio  vddio
D7  gndio  vddio
D8  gndio  vddio
D9  gndio  vddio  | Depending on IO usage
| D9  gndio  vswitch  | Depending on IO usage
E1  nc  vddio
E2  gndio  vddio
E3  gndio  vddio
E4  gndio  vddio
E5  gndio  vddio
E6  gndio  vddio
E7  gndio  vddio
E8  gndio  vddio
E9  gndio  vddio
F1  gndio  nc
F2  gndio  vddio
F3  gndio  vddio
F4  gndio  vddio
F5  gndio  vddio
F6  gndio  vddio
F7  gndio  vddio
F8  gndio  vddio
F9  gndio  vddio
G1  gndio  vddio
G2  gndio  vddio
G3  gndio  vddio
G4  gndio  vddio
G5  gndio  vddio
G6  gndio  vddio
G7  gndio  vddio
G8  gndio  vddio
G9  gndio  vddio
H1  gndio  vddio
H2  gndio  vddio
H3  gndio  vddio
H4  gndio  vddio
H5  gndio  vddio
H6  nc  nc
H7  gndio  vddio
H8  gndio  vddio
H9  gndio  nc
J1  nc  vddio
J2  gndio  nc
J3  gndio  vddio
J4  gndio  vddio
J5  nc  nc
J6  nc  nc
J7  gndio  vddio
J8  gndio  vddio
J9  nc  vddio
[Model Selector] io6usb_bmc_pd_cc_ft
usb_bmc_emit_pdccpd  "BMC PD emitter  + PD"
usb_bmc_emit_pdcc3a0  "BMC PD emitter  + 3rd PU"
usb_bmc_emit_pdcc1a5  "BMC PD emitter  + 2nd PU"
usb_bmc_emit_pdccusb  "BMC PD emitter  + 1st PU"
usb_bmc_emit  "BMC PD emitter "
io2_pdcc_ft_3v3_lowspeed  "GPIO-3.3V range - low speed"
io2_pdcc_ft_3v3_mediumspeed  "GPIO-3.3V range - medium speed"
io2_pdcc_ft_3v3_lowspeed_pu  "GPIO-3.3V range - low speed - pull up"
io2_pdcc_ft_3v3_mediumspeed_pu  "GPIO-3.3V range - medium speed - pull up"
io2_pdcc_ft_3v3_lowspeed_pd  "GPIO-3.3V range - low speed - pull down"
io2_pdcc_ft_3v3_mediumspeed_pd  "GPIO-3.3V range - medium speed - pull down"
io2_pdcc_ft_1v8_lowspeed  "GPIO-1.8V range - low speed"
io2_pdcc_ft_1v8_mediumspeed  "GPIO-1.8V range - medium speed"
io2_pdcc_ft_1v8_lowspeed_pu  "GPIO-1.8V range - low speed - pull up"
io2_pdcc_ft_1v8_mediumspeed_pu  "GPIO-1.8V range - medium speed - pull up"
io2_pdcc_ft_1v8_lowspeed_pd  "GPIO-1.8V range - low speed - pull down"
io2_pdcc_ft_1v8_mediumspeed_pd  "GPIO-1.8V range - medium speed - pull down"
io2_pdcc_ft_1v2_lowspeed  "GPIO-1.2V range - low speed"
io2_pdcc_ft_1v2_mediumspeed  "GPIO-1.2V range - medium speed"
io2_pdcc_ft_1v2_lowspeed_pu  "GPIO-1.2V range - low speed - pull up"
io2_pdcc_ft_1v2_mediumspeed_pu  "GPIO-1.2V range - medium speed - pull up"
io2_pdcc_ft_1v2_lowspeed_pd  "GPIO-1.2V range - low speed - pull down"
io2_pdcc_ft_1v2_mediumspeed_pd  "GPIO-1.2V range - medium speed - pull down"
[Model Selector] io8prog2m25m50m120m_sudq_ft
iols8p_sudq_ft_pd_lv  "IO low speed, PD=40kOhm - 1P8V"
iols8p_sudq_ft_pu_lv  "IO low speed, PU=40kOhm - 1P8V"
iols8p_sudq_ft_lv  "IO low speed - 1P8V"
iols8p_sudq_ft_pd  "IO low speed, PD=40kOhm - 3P3V"
iols8p_sudq_ft_pu  "IO low speed, PU=40kOhm - 3P3V"
iols8p_sudq_ft  "IO low speed - 3P3V"
iofs8p_sudq_ft_pd_lv  "IO full speed, PD=40kOhm - 1P8V"
iofs8p_sudq_ft_pu_lv  "IO full speed, PU=40kOhm - 1P8V"
iofs8p_sudq_ft_lv  "IO full speed - 1P8V"
iofs8p_sudq_ft_pd  "IO full speed, PD=40kOhm - 3P3V"
iofs8p_sudq_ft_pu  "IO full speed, PU=40kOhm - 3P3V"
iofs8p_sudq_ft  "IO full speed - 3P3V"
ioms8p_sudq_ft_pd_lv  "IO medium speed, PD=40kOhm - 1P8V"
ioms8p_sudq_ft_pu_lv  "IO medium speed, PU=40kOhm - 1P8V"
ioms8p_sudq_ft_lv  "IO medium speed - 1P8V"
ioms8p_sudq_ft_pd  "IO medium speed, PD=40kOhm - 3P3V"
ioms8p_sudq_ft_pu  "IO medium speed, PU=40kOhm - 3P3V"
ioms8p_sudq_ft  "IO medium speed - 3P3V"
iohs8p_sudq_ft_pd_lv  "IO high speed, PD=40kOhm - 1P8V"
iohs8p_sudq_ft_pu_lv  "IO high speed, PU=40kOhm - 1P8V"
iohs8p_sudq_ft_lv  "IO high speed - 1P8V"
iohs8p_sudq_ft_pd  "IO high speed, PD=40kOhm - 3P3V"
iohs8p_sudq_ft_pu  "IO high speed, PU=40kOhm - 3P3V"
iohs8p_sudq_ft  "IO high speed - 3P3V"
[Model Selector] io8prog2m25m50m120m_sudq_i2c_ft
io8prog_1v8_i2c_pd  "5V Tol GPIO 1.8V range i2c functionality with pull down"
io8prog_1v8_i2c_pu  "5V Tol GPIO 1.8V range i2c functionality with pull up"
io8prog_1v8_i2c  "5V Tol GPIO 1.8V range i2c functionality"
io8prog_3v3_i2c_pd  "5V Tol GPIO 3.3V range i2c functionality with pull down"
io8prog_3v3_i2c_pu  "5V Tol GPIO 3.3V range i2c functionality with pull up"
io8prog_3v3_i2c  "5V Tol GPIO 3.3V range i2c functionality"
iols8p_sudq_ft_pd_lv  "IO low speed, PD=40kOhm - 1P8V"
iols8p_sudq_ft_pu_lv  "IO low speed, PU=40kOhm - 1P8V"
iols8p_sudq_ft_lv  "IO low speed - 1P8V"
iols8p_sudq_ft_pd  "IO low speed, PD=40kOhm - 3P3V"
iols8p_sudq_ft_pu  "IO low speed, PU=40kOhm - 3P3V"
iols8p_sudq_ft  "IO low speed - 3P3V"
iofs8p_sudq_ft_pd_lv  "IO full speed, PD=40kOhm - 1P8V"
iofs8p_sudq_ft_pu_lv  "IO full speed, PU=40kOhm - 1P8V"
iofs8p_sudq_ft_lv  "IO full speed - 1P8V"
iofs8p_sudq_ft_pd  "IO full speed, PD=40kOhm - 3P3V"
iofs8p_sudq_ft_pu  "IO full speed, PU=40kOhm - 3P3V"
iofs8p_sudq_ft  "IO full speed - 3P3V"
ioms8p_sudq_ft_pd_lv  "IO medium speed, PD=40kOhm - 1P8V"
ioms8p_sudq_ft_pu_lv  "IO medium speed, PU=40kOhm - 1P8V"
ioms8p_sudq_ft_lv  "IO medium speed - 1P8V"
ioms8p_sudq_ft_pd  "IO medium speed, PD=40kOhm - 3P3V"
ioms8p_sudq_ft_pu  "IO medium speed, PU=40kOhm - 3P3V"
ioms8p_sudq_ft  "IO medium speed - 3P3V"
iohs8p_sudq_ft_pd_lv  "IO high speed, PD=40kOhm - 1P8V"
iohs8p_sudq_ft_pu_lv  "IO high speed, PU=40kOhm - 1P8V"
iohs8p_sudq_ft_lv  "IO high speed - 1P8V"
iohs8p_sudq_ft_pd  "IO high speed, PD=40kOhm - 3P3V"
iohs8p_sudq_ft_pu  "IO high speed, PU=40kOhm - 3P3V"
iohs8p_sudq_ft  "IO high speed - 3P3V"
[Model Selector] io8usblsfs_otg2
usb_ls_pd  "USB Low Speed mode - Pull Down"
usb_ls_pu2  "USB Low Speed mode - Pull up 2"
usb_ls_pu  "USB Low Speed mode - Pull up"
usb_fs  "USB Low Speed mode"
usb_fs_pd  "USB Full Speed mode - Pull Down"
usb_fs_pu2  "USB Full Speed mode - Pull up 2"
usb_fs_pu  "USB Full Speed mode - Pull up"
[Model Selector] ioreset_ft_v33
ioreset_1v2_pu  "RESET 1.2V range with PU"
ioreset_1v2  "RESET 1.2V range"
ioreset_1v8_pu  "RESET 1.8V range with PU"
ioreset_1v8  "RESET 1.8V range"
ioreset_3v3_pu  "RESET 3.3V range with PU"
ioreset_3v3  "RESET 3.3V range"
[Define Package Model]  stm32g471_473_474_483_484_wlcsp_81
[Manufacturer]  Unknown
[OEM]  Unknown
[Description]  None
[Number Of Pins]  79
[Pin Numbers]
| Pin Num   Terminal Name
D7 | PA0
E7 | PA1
G8 | PA2
H8 | PA3
D6 | PA4
F7 | PA5
G7 | PA6
J8 | PA7
D1 | PA8
D4 | PA9
D3 | PA10
C2 | PA11
C1 | PA12
B2 | PA13
C3 | PA14
A2 | PA15
F6 | PB0
G6 | PB1
J7 | PB2
A5 | PB3
C6 | PB4
A6 | PB5
B6 | PB6
C7 | PB7
A7 | PB9
H3 | PB10
H2 | PB11
G3 | PB12
H1 | PB13
G2 | PB14
E4 | PB15
B7 | PB8-BOOT0
E8 | PC0
C8 | PC1
F8 | PC2
G9 | PC3
E6 | PC4
H7 | PC5
E3 | PC6
D5 | PC7
C5 | PC8
D2 | PC9
B3 | PC10
C4 | PC11
A3 | PC12
B8 | PC13
C9 | PC14-OSC32_IN
D9 | PC15-OSC32_OUT
B4 | PD0
A4 | PD1
B5 | PD2
G1 | PD8
F3 | PD9
F2 | PD10
E2 | PD11
H5 | PE7
G5 | PE8
F5 | PE9
J4 | PE10
H4 | PE11
E5 | PE12
G4 | PE13
J3 | PE14
F4 | PE15
E9 | PF0-OSC_IN
F9 | PF1-OSC_OUT
D8 | PG10-NRST
B9 | VBAT
A1 | VDD
A9 | VDD
E1 | VDD
J1 | VDD
J9 | VDD
J5 | VDDA
J6 | VREF+
A8 | VSS
H9 | VSS
J2 | VSS
H6 | VSSA
|[Merged Pins]  A8
|B1  |  VSS
|F1  |  VSS
[Model Data]
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[End Model Data]
[End Package Model]
| Models and submodels in the file (66): usb_bmc_emit_pdccpd (I/O), usb_bmc_emit_pdcc3a0 (I/O), usb_bmc_emit_pdcc1a5 (I/O), usb_bmc_emit_pdccusb (I/O), usb_bmc_emit (I/O), io2_pdcc_ft_3v3_lowspeed (I/O), io2_pdcc_ft_3v3_mediumspeed (I/O), io2_pdcc_ft_3v3_lowspeed_pu (I/O), io2_pdcc_ft_3v3_mediumspeed_pu (I/O), io2_pdcc_ft_3v3_lowspeed_pd (I/O), io2_pdcc_ft_3v3_mediumspeed_pd (I/O), io2_pdcc_ft_1v8_lowspeed (I/O), io2_pdcc_ft_1v8_mediumspeed (I/O), io2_pdcc_ft_1v8_lowspeed_pu (I/O), io2_pdcc_ft_1v8_mediumspeed_pu (I/O), io2_pdcc_ft_1v8_lowspeed_pd (I/O), io2_pdcc_ft_1v8_mediumspeed_pd (I/O), io2_pdcc_ft_1v2_lowspeed (I/O), io2_pdcc_ft_1v2_mediumspeed (I/O), io2_pdcc_ft_1v2_lowspeed_pu (I/O), io2_pdcc_ft_1v2_mediumspeed_pu (I/O), io2_pdcc_ft_1v2_lowspeed_pd (I/O), io2_pdcc_ft_1v2_mediumspeed_pd (I/O), iols8p_sudq_ft_pd_lv (I/O), iols8p_sudq_ft_pu_lv (I/O), iols8p_sudq_ft_lv (I/O), iols8p_sudq_ft_pd (I/O), iols8p_sudq_ft_pu (I/O), iols8p_sudq_ft (I/O), iofs8p_sudq_ft_pd_lv (I/O), iofs8p_sudq_ft_pu_lv (I/O), iofs8p_sudq_ft_lv (I/O), iofs8p_sudq_ft_pd (I/O), iofs8p_sudq_ft_pu (I/O), iofs8p_sudq_ft (I/O), ioms8p_sudq_ft_pd_lv (I/O), ioms8p_sudq_ft_pu_lv (I/O), ioms8p_sudq_ft_lv (I/O), ioms8p_sudq_ft_pd (I/O), ioms8p_sudq_ft_pu (I/O), ioms8p_sudq_ft (I/O), iohs8p_sudq_ft_pd_lv (I/O), iohs8p_sudq_ft_pu_lv (I/O), iohs8p_sudq_ft_lv (I/O), iohs8p_sudq_ft_pd (I/O), iohs8p_sudq_ft_pu (I/O), iohs8p_sudq_ft (I/O), io8prog_1v8_i2c_pd (I/O), io8prog_1v8_i2c_pu (I/O), io8prog_1v8_i2c (I/O), io8prog_3v3_i2c_pd (I/O), io8prog_3v3_i2c_pu (I/O), io8prog_3v3_i2c (I/O), usb_ls_pd (I/O), usb_ls_pu2 (I/O), usb_ls_pu (I/O), usb_fs (I/O), usb_fs_pd (I/O), usb_fs_pu2 (I/O), usb_fs_pu (I/O), ioreset_1v2_pu (I/O_open_drain), ioreset_1v2 (I/O_open_drain), ioreset_1v8_pu (I/O_open_drain), ioreset_1v8 (I/O_open_drain), ioreset_3v3_pu (I/O_open_drain), ioreset_3v3 (I/O_open_drain)
