| IBIS file stm32g471_473_474_483_484_lqfp100.ibs
[IBIS ver]   4.2
[File name]  stm32g471_473_474_483_484_lqfp100.ibs
[File Rev]   1.0
[Date]   08-07-2019
[Source]   Data Created at STMicroelectronics
[Notes]   File originated from ELDO simulations.
[Disclaimer] This information is for modeling purpose only and is
   not guaranted. The information is subject to change without
   notice.
[Copyright]  Copyright 2019 STMicroelectronics Inc.
|   Component stm32g471_473_474_483_484_lqfp100
[Component] stm32g471_473_474_483_484_lqfp100
[Manufacturer] STMicroelectronics
[Package]
| variable   typ   min   max
R_pkg  0  NA  NA
L_pkg  0  NA  NA
C_pkg  0  NA  NA
[Pin]   signal_name   model_name
1  PE2  io8prog2m25m50m120m_sudq_ft
2  PE3  io8prog2m25m50m120m_sudq_ft
3  PE4  io8prog2m25m50m120m_sudq_ft
4  PE5  io8prog2m25m50m120m_sudq_ft
5  PE6  io8prog2m25m50m120m_sudq_ft
6  VBAT  power
7  PC13  io8prog2m25m50m120m_sudq_ft
8  PC14-OSC32_IN  io8prog2m25m50m120m_sudq_ft
9  PC15-OSC32_OUT  io8prog2m25m50m120m_sudq_ft
10  PF9  io8prog2m25m50m120m_sudq_ft
11  PF10  io8prog2m25m50m120m_sudq_ft
12  PF0-OSC_IN  io8prog2m25m50m120m_sudq_i2c_ft
13  PF1-OSC_OUT  io8prog2m25m50m120m_sudq_ft
14  PG10-NRST  ioreset_ft_v33
15  PC0  io8prog2m25m50m120m_sudq_ft
16  PC1  io8prog2m25m50m120m_sudq_ft
17  PC2  io8prog2m25m50m120m_sudq_ft
18  PC3  io8prog2m25m50m120m_sudq_ft
19  PF2  io8prog2m25m50m120m_sudq_ft
20  PA0  io8prog2m25m50m120m_sudq_ft
21  PA1  io8prog2m25m50m120m_sudq_ft
22  PA2  io8prog2m25m50m120m_sudq_ft
23  VSS  gnd
24  VDD  power
25  PA3  io8prog2m25m50m120m_sudq_ft
26  PA4  io8prog2m25m50m120m_sudq_ft
27  PA5  io8prog2m25m50m120m_sudq_ft
28  PA6  io8prog2m25m50m120m_sudq_ft
29  PA7  io8prog2m25m50m120m_sudq_ft
30  PC4  io8prog2m25m50m120m_sudq_i2c_ft
31  PC5  io8prog2m25m50m120m_sudq_ft
32  PB0  io8prog2m25m50m120m_sudq_ft
33  PB1  io8prog2m25m50m120m_sudq_ft
34  PB2  io8prog2m25m50m120m_sudq_ft
35  VSSA  nc
36  VREF+  nc
37  VDDA  nc
38  PE7  io8prog2m25m50m120m_sudq_ft
39  PE8  io8prog2m25m50m120m_sudq_ft
40  PE9  io8prog2m25m50m120m_sudq_ft
41  PE10  io8prog2m25m50m120m_sudq_ft
42  PE11  io8prog2m25m50m120m_sudq_ft
43  PE12  io8prog2m25m50m120m_sudq_ft
44  PE13  io8prog2m25m50m120m_sudq_ft
45  PE14  io8prog2m25m50m120m_sudq_ft
46  PE15  io8prog2m25m50m120m_sudq_ft
47  PB10  io8prog2m25m50m120m_sudq_ft
48  VSS  gnd
49  VDD  power
50  PB11  io8prog2m25m50m120m_sudq_ft
51  PB12  io8prog2m25m50m120m_sudq_ft
52  PB13  io8prog2m25m50m120m_sudq_ft
53  PB14  io8prog2m25m50m120m_sudq_ft
54  PB15  io8prog2m25m50m120m_sudq_ft
55  PD8  io8prog2m25m50m120m_sudq_ft
56  PD9  io8prog2m25m50m120m_sudq_ft
57  PD10  io8prog2m25m50m120m_sudq_ft
58  PD11  io8prog2m25m50m120m_sudq_ft
59  PD12  io8prog2m25m50m120m_sudq_ft
60  PD13  io8prog2m25m50m120m_sudq_ft
61  PD14  io8prog2m25m50m120m_sudq_ft
62  PD15  io8prog2m25m50m120m_sudq_ft
63  VSS  gnd
64  VDD  power
65  PC6  io8prog2m25m50m120m_sudq_i2c_ft
66  PC7  io8prog2m25m50m120m_sudq_i2c_ft
67  PC8  io8prog2m25m50m120m_sudq_i2c_ft
68  PC9  io8prog2m25m50m120m_sudq_i2c_ft
69  PA8  io8prog2m25m50m120m_sudq_ft
70  PA9  io8prog2m25m50m120m_sudq_i2c_ft
71  PA10  io8prog2m25m50m120m_sudq_i2c_ft
72  PA11  io8usblsfs_otg2
73  PA12  io8usblsfs_otg2
74  VSS  gnd
75  VDD  power
76  PA13  io8prog2m25m50m120m_sudq_i2c_ft
77  PA14  io8prog2m25m50m120m_sudq_i2c_ft
78  PA15  io8prog2m25m50m120m_sudq_i2c_ft
79  PC10  io8prog2m25m50m120m_sudq_ft
80  PC11  io8prog2m25m50m120m_sudq_i2c_ft
81  PC12  io8prog2m25m50m120m_sudq_ft
82  PD0  io8prog2m25m50m120m_sudq_ft
83  PD1  io8prog2m25m50m120m_sudq_ft
84  PD2  io8prog2m25m50m120m_sudq_ft
85  PD3  io8prog2m25m50m120m_sudq_ft
86  PD4  io8prog2m25m50m120m_sudq_ft
87  PD5  io8prog2m25m50m120m_sudq_ft
88  PD6  io8prog2m25m50m120m_sudq_ft
89  PD7  io8prog2m25m50m120m_sudq_ft
90  PB3  io8prog2m25m50m120m_sudq_ft
91  PB4  io6usb_bmc_pd_cc_ft
92  PB5  io8prog2m25m50m120m_sudq_i2c_ft
93  PB6  io6usb_bmc_pd_cc_ft
94  PB7  io8prog2m25m50m120m_sudq_i2c_ft
95  PB8-BOOT0  io8prog2m25m50m120m_sudq_i2c_ft
96  PB9  io8prog2m25m50m120m_sudq_i2c_ft
97  PE0  io8prog2m25m50m120m_sudq_ft
98  PE1  io8prog2m25m50m120m_sudq_ft
99  VSS  gnd
100  VDD  power
[Package Model]   stm32g471_473_474_483_484_lqfp_100
[Pin Mapping]   pulldown_ref   pullup_ref   | Comment
1  gndio  vddio
2  gndio  vddio
3  gndio  vddio
4  gndio  vddio
5  gndio  vddio
6  nc  vswitch
7  gndio  vddio  | Depending on IO usage
| 7  gndio  vswitch  | Depending on IO usage
8  gndio  vddio  | Depending on IO usage
| 8  gndio  vswitch  | Depending on IO usage
9  gndio  vddio  | Depending on IO usage
| 9  gndio  vswitch  | Depending on IO usage
10  gndio  vddio
11  gndio  vddio
12  gndio  vddio
13  gndio  vddio
14  gndio  vddio
15  gndio  vddio
16  gndio  vddio
17  gndio  vddio
18  gndio  vddio
19  gndio  vddio
20  gndio  vddio
21  gndio  vddio
22  gndio  vddio
23  gndio  nc
24  nc  vddio
25  gndio  vddio
26  gndio  vddio
27  gndio  vddio
28  gndio  vddio
29  gndio  vddio
30  gndio  vddio
31  gndio  vddio
32  gndio  vddio
33  gndio  vddio
34  gndio  vddio
35  nc  nc
36  nc  nc
37  nc  nc
38  gndio  vddio
39  gndio  vddio
40  gndio  vddio
41  gndio  vddio
42  gndio  vddio
43  gndio  vddio
44  gndio  vddio
45  gndio  vddio
46  gndio  vddio
47  gndio  vddio
48  gndio  nc
49  nc  vddio
50  gndio  vddio
51  gndio  vddio
52  gndio  vddio
53  gndio  vddio
54  gndio  vddio
55  gndio  vddio
56  gndio  vddio
57  gndio  vddio
58  gndio  vddio
59  gndio  vddio
60  gndio  vddio
61  gndio  vddio
62  gndio  vddio
63  gndio  nc
64  nc  vddio
65  gndio  vddio
66  gndio  vddio
67  gndio  vddio
68  gndio  vddio
69  gndio  vddio
70  gndio  vddio
71  gndio  vddio
72  gndio  vddio
73  gndio  vddio
74  gndio  nc
75  nc  vddio
76  gndio  vddio
77  gndio  vddio
78  gndio  vddio
79  gndio  vddio
80  gndio  vddio
81  gndio  vddio
82  gndio  vddio
83  gndio  vddio
84  gndio  vddio
85  gndio  vddio
86  gndio  vddio
87  gndio  vddio
88  gndio  vddio
89  gndio  vddio
90  gndio  vddio
91  gndio  vddio
92  gndio  vddio
93  gndio  vddio
94  gndio  vddio
95  gndio  vddio
96  gndio  vddio
97  gndio  vddio
98  gndio  vddio
99  gndio  nc
100  nc  vddio
[Model Selector] io6usb_bmc_pd_cc_ft
usb_bmc_emit_pdccpd  "BMC PD emitter  + PD"
usb_bmc_emit_pdcc3a0  "BMC PD emitter  + 3rd PU"
usb_bmc_emit_pdcc1a5  "BMC PD emitter  + 2nd PU"
usb_bmc_emit_pdccusb  "BMC PD emitter  + 1st PU"
usb_bmc_emit  "BMC PD emitter "
io2_pdcc_ft_3v3_lowspeed  "GPIO-3.3V range - low speed"
io2_pdcc_ft_3v3_mediumspeed  "GPIO-3.3V range - medium speed"
io2_pdcc_ft_3v3_lowspeed_pu  "GPIO-3.3V range - low speed - pull up"
io2_pdcc_ft_3v3_mediumspeed_pu  "GPIO-3.3V range - medium speed - pull up"
io2_pdcc_ft_3v3_lowspeed_pd  "GPIO-3.3V range - low speed - pull down"
io2_pdcc_ft_3v3_mediumspeed_pd  "GPIO-3.3V range - medium speed - pull down"
io2_pdcc_ft_1v8_lowspeed  "GPIO-1.8V range - low speed"
io2_pdcc_ft_1v8_mediumspeed  "GPIO-1.8V range - medium speed"
io2_pdcc_ft_1v8_lowspeed_pu  "GPIO-1.8V range - low speed - pull up"
io2_pdcc_ft_1v8_mediumspeed_pu  "GPIO-1.8V range - medium speed - pull up"
io2_pdcc_ft_1v8_lowspeed_pd  "GPIO-1.8V range - low speed - pull down"
io2_pdcc_ft_1v8_mediumspeed_pd  "GPIO-1.8V range - medium speed - pull down"
io2_pdcc_ft_1v2_lowspeed  "GPIO-1.2V range - low speed"
io2_pdcc_ft_1v2_mediumspeed  "GPIO-1.2V range - medium speed"
io2_pdcc_ft_1v2_lowspeed_pu  "GPIO-1.2V range - low speed - pull up"
io2_pdcc_ft_1v2_mediumspeed_pu  "GPIO-1.2V range - medium speed - pull up"
io2_pdcc_ft_1v2_lowspeed_pd  "GPIO-1.2V range - low speed - pull down"
io2_pdcc_ft_1v2_mediumspeed_pd  "GPIO-1.2V range - medium speed - pull down"
[Model Selector] io8prog2m25m50m120m_sudq_ft
iols8p_sudq_ft_pd_lv  "IO low speed, PD=40kOhm - 1P8V"
iols8p_sudq_ft_pu_lv  "IO low speed, PU=40kOhm - 1P8V"
iols8p_sudq_ft_lv  "IO low speed - 1P8V"
iols8p_sudq_ft_pd  "IO low speed, PD=40kOhm - 3P3V"
iols8p_sudq_ft_pu  "IO low speed, PU=40kOhm - 3P3V"
iols8p_sudq_ft  "IO low speed - 3P3V"
iofs8p_sudq_ft_pd_lv  "IO full speed, PD=40kOhm - 1P8V"
iofs8p_sudq_ft_pu_lv  "IO full speed, PU=40kOhm - 1P8V"
iofs8p_sudq_ft_lv  "IO full speed - 1P8V"
iofs8p_sudq_ft_pd  "IO full speed, PD=40kOhm - 3P3V"
iofs8p_sudq_ft_pu  "IO full speed, PU=40kOhm - 3P3V"
iofs8p_sudq_ft  "IO full speed - 3P3V"
ioms8p_sudq_ft_pd_lv  "IO medium speed, PD=40kOhm - 1P8V"
ioms8p_sudq_ft_pu_lv  "IO medium speed, PU=40kOhm - 1P8V"
ioms8p_sudq_ft_lv  "IO medium speed - 1P8V"
ioms8p_sudq_ft_pd  "IO medium speed, PD=40kOhm - 3P3V"
ioms8p_sudq_ft_pu  "IO medium speed, PU=40kOhm - 3P3V"
ioms8p_sudq_ft  "IO medium speed - 3P3V"
iohs8p_sudq_ft_pd_lv  "IO high speed, PD=40kOhm - 1P8V"
iohs8p_sudq_ft_pu_lv  "IO high speed, PU=40kOhm - 1P8V"
iohs8p_sudq_ft_lv  "IO high speed - 1P8V"
iohs8p_sudq_ft_pd  "IO high speed, PD=40kOhm - 3P3V"
iohs8p_sudq_ft_pu  "IO high speed, PU=40kOhm - 3P3V"
iohs8p_sudq_ft  "IO high speed - 3P3V"
[Model Selector] io8prog2m25m50m120m_sudq_i2c_ft
io8prog_1v8_i2c_pd  "5V Tol GPIO 1.8V range i2c functionality with pull down"
io8prog_1v8_i2c_pu  "5V Tol GPIO 1.8V range i2c functionality with pull up"
io8prog_1v8_i2c  "5V Tol GPIO 1.8V range i2c functionality"
io8prog_3v3_i2c_pd  "5V Tol GPIO 3.3V range i2c functionality with pull down"
io8prog_3v3_i2c_pu  "5V Tol GPIO 3.3V range i2c functionality with pull up"
io8prog_3v3_i2c  "5V Tol GPIO 3.3V range i2c functionality"
iols8p_sudq_ft_pd_lv  "IO low speed, PD=40kOhm - 1P8V"
iols8p_sudq_ft_pu_lv  "IO low speed, PU=40kOhm - 1P8V"
iols8p_sudq_ft_lv  "IO low speed - 1P8V"
iols8p_sudq_ft_pd  "IO low speed, PD=40kOhm - 3P3V"
iols8p_sudq_ft_pu  "IO low speed, PU=40kOhm - 3P3V"
iols8p_sudq_ft  "IO low speed - 3P3V"
iofs8p_sudq_ft_pd_lv  "IO full speed, PD=40kOhm - 1P8V"
iofs8p_sudq_ft_pu_lv  "IO full speed, PU=40kOhm - 1P8V"
iofs8p_sudq_ft_lv  "IO full speed - 1P8V"
iofs8p_sudq_ft_pd  "IO full speed, PD=40kOhm - 3P3V"
iofs8p_sudq_ft_pu  "IO full speed, PU=40kOhm - 3P3V"
iofs8p_sudq_ft  "IO full speed - 3P3V"
ioms8p_sudq_ft_pd_lv  "IO medium speed, PD=40kOhm - 1P8V"
ioms8p_sudq_ft_pu_lv  "IO medium speed, PU=40kOhm - 1P8V"
ioms8p_sudq_ft_lv  "IO medium speed - 1P8V"
ioms8p_sudq_ft_pd  "IO medium speed, PD=40kOhm - 3P3V"
ioms8p_sudq_ft_pu  "IO medium speed, PU=40kOhm - 3P3V"
ioms8p_sudq_ft  "IO medium speed - 3P3V"
iohs8p_sudq_ft_pd_lv  "IO high speed, PD=40kOhm - 1P8V"
iohs8p_sudq_ft_pu_lv  "IO high speed, PU=40kOhm - 1P8V"
iohs8p_sudq_ft_lv  "IO high speed - 1P8V"
iohs8p_sudq_ft_pd  "IO high speed, PD=40kOhm - 3P3V"
iohs8p_sudq_ft_pu  "IO high speed, PU=40kOhm - 3P3V"
iohs8p_sudq_ft  "IO high speed - 3P3V"
[Model Selector] io8usblsfs_otg2
usb_ls_pd  "USB Low Speed mode - Pull Down"
usb_ls_pu2  "USB Low Speed mode - Pull up 2"
usb_ls_pu  "USB Low Speed mode - Pull up"
usb_fs  "USB Low Speed mode"
usb_fs_pd  "USB Full Speed mode - Pull Down"
usb_fs_pu2  "USB Full Speed mode - Pull up 2"
usb_fs_pu  "USB Full Speed mode - Pull up"
[Model Selector] ioreset_ft_v33
ioreset_1v2_pu  "RESET 1.2V range with PU"
ioreset_1v2  "RESET 1.2V range"
ioreset_1v8_pu  "RESET 1.8V range with PU"
ioreset_1v8  "RESET 1.8V range"
ioreset_3v3_pu  "RESET 3.3V range with PU"
ioreset_3v3  "RESET 3.3V range"
[Define Package Model]  stm32g471_473_474_483_484_lqfp_100
[Manufacturer]  Unknown
[OEM]  Unknown
[Description]  None
[Number Of Pins]  100
[Pin Numbers]
| Pin Num   Terminal Name
20 | PA0
21 | PA1
22 | PA2
25 | PA3
26 | PA4
27 | PA5
28 | PA6
29 | PA7
69 | PA8
70 | PA9
71 | PA10
72 | PA11
73 | PA12
76 | PA13
77 | PA14
78 | PA15
32 | PB0
33 | PB1
34 | PB2
90 | PB3
91 | PB4
92 | PB5
93 | PB6
94 | PB7
96 | PB9
47 | PB10
50 | PB11
51 | PB12
52 | PB13
53 | PB14
54 | PB15
95 | PB8-BOOT0
15 | PC0
16 | PC1
17 | PC2
18 | PC3
30 | PC4
31 | PC5
65 | PC6
66 | PC7
67 | PC8
68 | PC9
79 | PC10
80 | PC11
81 | PC12
7 | PC13
8 | PC14-OSC32_IN
9 | PC15-OSC32_OUT
82 | PD0
83 | PD1
84 | PD2
85 | PD3
86 | PD4
87 | PD5
88 | PD6
89 | PD7
55 | PD8
56 | PD9
57 | PD10
58 | PD11
59 | PD12
60 | PD13
61 | PD14
62 | PD15
97 | PE0
98 | PE1
1 | PE2
2 | PE3
3 | PE4
4 | PE5
5 | PE6
38 | PE7
39 | PE8
40 | PE9
41 | PE10
42 | PE11
43 | PE12
44 | PE13
45 | PE14
46 | PE15
19 | PF2
10 | PF9
11 | PF10
12 | PF0-OSC_IN
13 | PF1-OSC_OUT
14 | PG10-NRST
6 | VBAT
24 | VDD
49 | VDD
64 | VDD
75 | VDD
100 | VDD
37 | VDDA
36 | VREF+
23 | VSS
48 | VSS
63 | VSS
74 | VSS
99 | VSS
35 | VSSA
[Model Data]
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[End Model Data]
[End Package Model]
| Models and submodels in the file (66): usb_bmc_emit_pdccpd (I/O), usb_bmc_emit_pdcc3a0 (I/O), usb_bmc_emit_pdcc1a5 (I/O), usb_bmc_emit_pdccusb (I/O), usb_bmc_emit (I/O), io2_pdcc_ft_3v3_lowspeed (I/O), io2_pdcc_ft_3v3_mediumspeed (I/O), io2_pdcc_ft_3v3_lowspeed_pu (I/O), io2_pdcc_ft_3v3_mediumspeed_pu (I/O), io2_pdcc_ft_3v3_lowspeed_pd (I/O), io2_pdcc_ft_3v3_mediumspeed_pd (I/O), io2_pdcc_ft_1v8_lowspeed (I/O), io2_pdcc_ft_1v8_mediumspeed (I/O), io2_pdcc_ft_1v8_lowspeed_pu (I/O), io2_pdcc_ft_1v8_mediumspeed_pu (I/O), io2_pdcc_ft_1v8_lowspeed_pd (I/O), io2_pdcc_ft_1v8_mediumspeed_pd (I/O), io2_pdcc_ft_1v2_lowspeed (I/O), io2_pdcc_ft_1v2_mediumspeed (I/O), io2_pdcc_ft_1v2_lowspeed_pu (I/O), io2_pdcc_ft_1v2_mediumspeed_pu (I/O), io2_pdcc_ft_1v2_lowspeed_pd (I/O), io2_pdcc_ft_1v2_mediumspeed_pd (I/O), iols8p_sudq_ft_pd_lv (I/O), iols8p_sudq_ft_pu_lv (I/O), iols8p_sudq_ft_lv (I/O), iols8p_sudq_ft_pd (I/O), iols8p_sudq_ft_pu (I/O), iols8p_sudq_ft (I/O), iofs8p_sudq_ft_pd_lv (I/O), iofs8p_sudq_ft_pu_lv (I/O), iofs8p_sudq_ft_lv (I/O), iofs8p_sudq_ft_pd (I/O), iofs8p_sudq_ft_pu (I/O), iofs8p_sudq_ft (I/O), ioms8p_sudq_ft_pd_lv (I/O), ioms8p_sudq_ft_pu_lv (I/O), ioms8p_sudq_ft_lv (I/O), ioms8p_sudq_ft_pd (I/O), ioms8p_sudq_ft_pu (I/O), ioms8p_sudq_ft (I/O), iohs8p_sudq_ft_pd_lv (I/O), iohs8p_sudq_ft_pu_lv (I/O), iohs8p_sudq_ft_lv (I/O), iohs8p_sudq_ft_pd (I/O), iohs8p_sudq_ft_pu (I/O), iohs8p_sudq_ft (I/O), io8prog_1v8_i2c_pd (I/O), io8prog_1v8_i2c_pu (I/O), io8prog_1v8_i2c (I/O), io8prog_3v3_i2c_pd (I/O), io8prog_3v3_i2c_pu (I/O), io8prog_3v3_i2c (I/O), usb_ls_pd (I/O), usb_ls_pu2 (I/O), usb_ls_pu (I/O), usb_fs (I/O), usb_fs_pd (I/O), usb_fs_pu2 (I/O), usb_fs_pu (I/O), ioreset_1v2_pu (I/O_open_drain), ioreset_1v2 (I/O_open_drain), ioreset_1v8_pu (I/O_open_drain), ioreset_1v8 (I/O_open_drain), ioreset_3v3_pu (I/O_open_drain), ioreset_3v3 (I/O_open_drain)
