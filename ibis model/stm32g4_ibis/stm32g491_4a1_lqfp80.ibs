| IBIS file stm32g491_4a1_lqfp80.ibs
[IBIS ver] 4.2
[File name] stm32g491_4a1_lqfp80.ibs
[File Rev] 1.0
[Date]  29-07-2024
[Source] Data Created at STMicroelectronics
[Notes]  File originated from ELDO simulations.
[Disclaimer]  This information is for modeling purpose only and is
   not guaranteed. The information is subject to change without
   notice.
[Copyright] Copyright 2024 STMicroelectronics Inc.
|   Component stm32g491_4a1_lqfp80
[Component] stm32g491_4a1_lqfp80
[Manufacturer] STMicroelectronics
[Package]
| variable   typ   min   max
R_pkg  0  NA  NA
L_pkg  0  NA  NA
C_pkg  0  NA  NA
[Pin]   signal_name   model_name R_pin  L_pin C_pin
1 VBAT POWER 0.125344562 6.20552E-09 5.24E-15
2 PC13 io8prog2m25m50m120m_sudq_i2c_ft 0.120515446 5.99116E-09 7.82E-15
3 PC14-OSC32_IN io8prog2m25m50m120m_sudq_i2c_ft 0.12047071 5.94998E-09 6.53E-15
4 PC15-OSC32_OUT io8prog2m25m50m120m_sudq_ft 0.117880646 5.78336E-09 6.23E-15
5 PF0-OSC_IN io8prog2m25m50m120m_sudq_ft 0.117278614 5.65387E-09 3.11E-15
6 PF1-OSC_OUT io8prog2m25m50m120m_sudq_ft 0.11554812 5.54782E-09 1.39E-15
7 PG10-NRST ioreset_ft_v33 0.114995632 5.4344E-09 2.92E-15
8 PC0 io8prog2m25m50m120m_sudq_ft 0.112975638 5.2963E-09 3.56E-15
9 PC1 io8prog2m25m50m120m_sudq_ft 0.111323436 5.23061E-09 4.78E-15
10 PC2 io8prog2m25m50m120m_sudq_ft 0.109216856 5.14191E-09 8.66E-15
11 PC3 io8prog2m25m50m120m_sudq_ft 0.11066442 5.17991E-09 9.03E-15
12 PA0 io8prog2m25m50m120m_sudq_ft 0.110607546 5.19248E-09 7.98E-15
13 PA1 io8prog2m25m50m120m_sudq_ft 0.111326184 5.25166E-09 1.03E-14
14 PA2 io8prog2m25m50m120m_sudq_ft 0.11442005 5.34504E-09 7.00E-15
15 VSS GND 0.114363236 5.45423E-09 8.65E-15
16 VDD POWER 0.117563732 5.62144E-09 7.83E-15
17 PA3 io8prog2m25m50m120m_sudq_ft 0.119904688 5.80037E-09 2.29E-16
18 PA4 io8prog2m25m50m120m_sudq_ft 0.122311852 5.96269E-09 1.05E-15
19 PA5 io8prog2m25m50m120m_sudq_ft 0.125384354 6.18685E-09 8.12E-16
20 PA6 io8prog2m25m50m120m_sudq_ft 0.129702038 6.48502E-09 3.82E-15
21 PA7 io8prog2m25m50m120m_sudq_ft 0.125344562 6.20552E-09 5.24E-15
22 PC4 io8prog2m25m50m120m_sudq_ft 0.120515446 5.99116E-09 7.82E-15
23 PC5 io8prog2m25m50m120m_sudq_ft 0.12047071 5.94998E-09 6.53E-15
24 PB0 io8prog2m25m50m120m_sudq_ft 0.117880646 5.78336E-09 6.23E-15
25 PB1 io8prog2m25m50m120m_sudq_ft 0.117278614 5.65387E-09 3.11E-15
26 PB2 io8prog2m25m50m120m_sudq_ft 0.11554812 5.54782E-09 1.39E-15
27 VSSA GND 0.114995632 5.4344E-09 2.92E-15
28 VREF+ POWER 0.112975638 5.2963E-09 3.56E-15
29 VDDA POWER 0.111323436 5.23061E-09 4.78E-15
30 PE7 io8prog2m25m50m120m_sudq_ft 0.109216856 5.14191E-09 8.66E-15
31 PE8 io8prog2m25m50m120m_sudq_ft 0.11066442 5.17991E-09 9.03E-15
32 PE9 io8prog2m25m50m120m_sudq_ft 0.110607546 5.19248E-09 7.98E-15
33 PE10 io8prog2m25m50m120m_sudq_ft 0.111326184 5.25166E-09 1.03E-14
34 PE11 io8prog2m25m50m120m_sudq_ft 0.11442005 5.34504E-09 7.00E-15
35 PE12 io8prog2m25m50m120m_sudq_ft 0.114363236 5.45423E-09 8.65E-15
36 PE13 io8prog2m25m50m120m_sudq_ft 0.117563732 5.62144E-09 7.83E-15
37 PE14 io8prog2m25m50m120m_sudq_ft 0.119904688 5.80037E-09 2.29E-16
38 PE15 io8prog2m25m50m120m_sudq_ft 0.122311852 5.96269E-09 1.05E-15
39 PB10 io8prog2m25m50m120m_sudq_ft 0.125384354 6.18685E-09 8.12E-16
40 VSS GND 0.129702038 6.48502E-09 3.82E-15
41 VDD POWER 0.125344562 6.20552E-09 5.24E-15
42 PB11 io8prog2m25m50m120m_sudq_ft 0.120515446 5.99116E-09 7.82E-15
43 PB12 io8prog2m25m50m120m_sudq_ft 0.12047071 5.94998E-09 6.53E-15
44 PB13 io8prog2m25m50m120m_sudq_ft 0.117880646 5.78336E-09 6.23E-15
45 PB14 io8prog2m25m50m120m_sudq_ft 0.117278614 5.65387E-09 3.11E-15
46 PB15 io8prog2m25m50m120m_sudq_ft 0.11554812 5.54782E-09 1.39E-15
47 PD8 io8prog2m25m50m120m_sudq_ft 0.114995632 5.4344E-09 2.92E-15
48 PD9 io8prog2m25m50m120m_sudq_ft 0.112975638 5.2963E-09 3.56E-15
49 PD10 io8prog2m25m50m120m_sudq_ft 0.111323436 5.23061E-09 4.78E-15
50 VSS GND 0.109216856 5.14191E-09 8.66E-15
51 VDD POWER 0.11066442 5.17991E-09 9.03E-15
52 PC6 io8prog2m25m50m120m_sudq_i2c_ft 0.110607546 5.19248E-09 7.98E-15
53 PC7 io8prog2m25m50m120m_sudq_i2c_ft 0.111326184 5.25166E-09 1.03E-14
54 PC8 io8prog2m25m50m120m_sudq_i2c_ft 0.11442005 5.34504E-09 7.00E-15
55 PC9 io8prog2m25m50m120m_sudq_i2c_ft 0.114363236 5.45423E-09 8.65E-15
56 PA8 io8prog2m25m50m120m_sudq_ft 0.117563732 5.62144E-09 7.83E-15
57 PA9 io8prog2m25m50m120m_sudq_i2c_ft 0.119904688 5.80037E-09 2.29E-16
58 PA10 io8prog2m25m50m120m_sudq_ft 0.122311852 5.96269E-09 1.05E-15
59 PA11 io8usblsfs_otg2 0.125384354 6.18685E-09 8.12E-16
60 PA12 io8usblsfs_otg2 0.129702038 6.48502E-09 3.82E-15
61 VSS GND 0.125344562 6.20552E-09 5.24E-15
62 VDD POWER 0.120515446 5.99116E-09 7.82E-15
63 PA13 io8prog2m25m50m120m_sudq_i2c_ft 0.12047071 5.94998E-09 6.53E-15
64 PA14 io8prog2m25m50m120m_sudq_ft 0.117880646 5.78336E-09 6.23E-15
65 PA15 io8prog2m25m50m120m_sudq_i2c_ft 0.117278614 5.65387E-09 3.11E-15
66 PC10 io8prog2m25m50m120m_sudq_ft 0.11554812 5.54782E-09 1.39E-15
67 PC11 io8prog2m25m50m120m_sudq_i2c_ft 0.114995632 5.4344E-09 2.92E-15
68 PC12 io8prog2m25m50m120m_sudq_ft 0.112975638 5.2963E-09 3.56E-15
69 PD0 io8prog2m25m50m120m_sudq_ft 0.111323436 5.23061E-09 4.78E-15
70 PD1 io8prog2m25m50m120m_sudq_ft 0.109216856 5.14191E-09 8.66E-15
71 PD2 io8prog2m25m50m120m_sudq_ft 0.11066442 5.17991E-09 9.03E-15
72 PB3 io8prog2m25m50m120m_sudq_ft 0.110607546 5.19248E-09 7.98E-15
73 PB4 io6usb_bmc_pd_cc_ft 0.111326184 5.25166E-09 1.03E-14
74 PB5 io8prog2m25m50m120m_sudq_ft 0.11442005 5.34504E-09 7.00E-15
75 PB6 io6usb_bmc_pd_cc_ft 0.114363236 5.45423E-09 8.65E-15
76 PB7 io8prog2m25m50m120m_sudq_i2c_ft 0.117563732 5.62144E-09 7.83E-15
77 PB8-BOOT0 io8prog2m25m50m120m_sudq_i2c_ft 0.119904688 5.80037E-09 2.29E-16
78 PB9 io8prog2m25m50m120m_sudq_i2c_ft 0.122311852 5.96269E-09 1.05E-15
79 VSS GND 0.125384354 6.18685E-09 8.12E-16
80 VDD POWER 0.129702038 6.48502E-09 3.82E-15
[Model Selector] io6usb_bmc_pd_cc_ft
usb_bmc_emit_pdccpd  "BMC PD emitter  + PD"
usb_bmc_emit_pdcc3a0  "BMC PD emitter  + 3rd PU"
usb_bmc_emit_pdcc1a5  "BMC PD emitter  + 2nd PU"
usb_bmc_emit_pdccusb  "BMC PD emitter  + 1st PU"
usb_bmc_emit  "BMC PD emitter "
io2_pdcc_ft_3v3_lowspeed  "GPIO-3.3V range - low speed"
io2_pdcc_ft_3v3_mediumspeed  "GPIO-3.3V range - medium speed"
io2_pdcc_ft_3v3_lowspeed_pu  "GPIO-3.3V range - low speed - pull up"
io2_pdcc_ft_3v3_mediumspeed_pu  "GPIO-3.3V range - medium speed - pull up"
io2_pdcc_ft_3v3_lowspeed_pd  "GPIO-3.3V range - low speed - pull down"
io2_pdcc_ft_3v3_mediumspeed_pd  "GPIO-3.3V range - medium speed - pull down"
io2_pdcc_ft_1v8_lowspeed  "GPIO-1.8V range - low speed"
io2_pdcc_ft_1v8_mediumspeed  "GPIO-1.8V range - medium speed"
io2_pdcc_ft_1v8_lowspeed_pu  "GPIO-1.8V range - low speed - pull up"
io2_pdcc_ft_1v8_mediumspeed_pu  "GPIO-1.8V range - medium speed - pull up"
io2_pdcc_ft_1v8_lowspeed_pd  "GPIO-1.8V range - low speed - pull down"
io2_pdcc_ft_1v8_mediumspeed_pd  "GPIO-1.8V range - medium speed - pull down"
io2_pdcc_ft_1v2_lowspeed  "GPIO-1.2V range - low speed"
io2_pdcc_ft_1v2_mediumspeed  "GPIO-1.2V range - medium speed"
io2_pdcc_ft_1v2_lowspeed_pu  "GPIO-1.2V range - low speed - pull up"
io2_pdcc_ft_1v2_mediumspeed_pu  "GPIO-1.2V range - medium speed - pull up"
io2_pdcc_ft_1v2_lowspeed_pd  "GPIO-1.2V range - low speed - pull down"
io2_pdcc_ft_1v2_mediumspeed_pd  "GPIO-1.2V range - medium speed - pull down"
[Model Selector] io8prog2m25m50m120m_sudq_ft
iols8p_sudq_ft_pd_lv  "IO low speed, PD=40kOhm - 1P8V"
iols8p_sudq_ft_pu_lv  "IO low speed, PU=40kOhm - 1P8V"
iols8p_sudq_ft_lv  "IO low speed - 1P8V"
iols8p_sudq_ft_pd  "IO low speed, PD=40kOhm - 3P3V"
iols8p_sudq_ft_pu  "IO low speed, PU=40kOhm - 3P3V"
iols8p_sudq_ft  "IO low speed - 3P3V"
iofs8p_sudq_ft_pd_lv  "IO full speed, PD=40kOhm - 1P8V"
iofs8p_sudq_ft_pu_lv  "IO full speed, PU=40kOhm - 1P8V"
iofs8p_sudq_ft_lv  "IO full speed - 1P8V"
iofs8p_sudq_ft_pd  "IO full speed, PD=40kOhm - 3P3V"
iofs8p_sudq_ft_pu  "IO full speed, PU=40kOhm - 3P3V"
iofs8p_sudq_ft  "IO full speed - 3P3V"
ioms8p_sudq_ft_pd_lv  "IO medium speed, PD=40kOhm - 1P8V"
ioms8p_sudq_ft_pu_lv  "IO medium speed, PU=40kOhm - 1P8V"
ioms8p_sudq_ft_lv  "IO medium speed - 1P8V"
ioms8p_sudq_ft_pd  "IO medium speed, PD=40kOhm - 3P3V"
ioms8p_sudq_ft_pu  "IO medium speed, PU=40kOhm - 3P3V"
ioms8p_sudq_ft  "IO medium speed - 3P3V"
iohs8p_sudq_ft_pd_lv  "IO high speed, PD=40kOhm - 1P8V"
iohs8p_sudq_ft_pu_lv  "IO high speed, PU=40kOhm - 1P8V"
iohs8p_sudq_ft_lv  "IO high speed - 1P8V"
iohs8p_sudq_ft_pd  "IO high speed, PD=40kOhm - 3P3V"
iohs8p_sudq_ft_pu  "IO high speed, PU=40kOhm - 3P3V"
iohs8p_sudq_ft  "IO high speed - 3P3V"
[Model Selector] io8prog2m25m50m120m_sudq_i2c_ft
io8prog_1v8_i2c_pd  "5V Tol GPIO 1.8V range i2c functionality with pull down"
io8prog_1v8_i2c_pu  "5V Tol GPIO 1.8V range i2c functionality with pull up"
io8prog_1v8_i2c  "5V Tol GPIO 1.8V range i2c functionality"
io8prog_3v3_i2c_pd  "5V Tol GPIO 3.3V range i2c functionality with pull down"
io8prog_3v3_i2c_pu  "5V Tol GPIO 3.3V range i2c functionality with pull up"
io8prog_3v3_i2c  "5V Tol GPIO 3.3V range i2c functionality"
iols8p_sudq_ft_pd_lv  "IO low speed, PD=40kOhm - 1P8V"
iols8p_sudq_ft_pu_lv  "IO low speed, PU=40kOhm - 1P8V"
iols8p_sudq_ft_lv  "IO low speed - 1P8V"
iols8p_sudq_ft_pd  "IO low speed, PD=40kOhm - 3P3V"
iols8p_sudq_ft_pu  "IO low speed, PU=40kOhm - 3P3V"
iols8p_sudq_ft  "IO low speed - 3P3V"
iofs8p_sudq_ft_pd_lv  "IO full speed, PD=40kOhm - 1P8V"
iofs8p_sudq_ft_pu_lv  "IO full speed, PU=40kOhm - 1P8V"
iofs8p_sudq_ft_lv  "IO full speed - 1P8V"
iofs8p_sudq_ft_pd  "IO full speed, PD=40kOhm - 3P3V"
iofs8p_sudq_ft_pu  "IO full speed, PU=40kOhm - 3P3V"
iofs8p_sudq_ft  "IO full speed - 3P3V"
ioms8p_sudq_ft_pd_lv  "IO medium speed, PD=40kOhm - 1P8V"
ioms8p_sudq_ft_pu_lv  "IO medium speed, PU=40kOhm - 1P8V"
ioms8p_sudq_ft_lv  "IO medium speed - 1P8V"
ioms8p_sudq_ft_pd  "IO medium speed, PD=40kOhm - 3P3V"
ioms8p_sudq_ft_pu  "IO medium speed, PU=40kOhm - 3P3V"
ioms8p_sudq_ft  "IO medium speed - 3P3V"
iohs8p_sudq_ft_pd_lv  "IO high speed, PD=40kOhm - 1P8V"
iohs8p_sudq_ft_pu_lv  "IO high speed, PU=40kOhm - 1P8V"
iohs8p_sudq_ft_lv  "IO high speed - 1P8V"
iohs8p_sudq_ft_pd  "IO high speed, PD=40kOhm - 3P3V"
iohs8p_sudq_ft_pu  "IO high speed, PU=40kOhm - 3P3V"
iohs8p_sudq_ft  "IO high speed - 3P3V"
[Model Selector] io8usblsfs_otg2
usb_ls_pd  "USB Low Speed mode - Pull Down"
usb_ls_pu2  "USB Low Speed mode - Pull up 2"
usb_ls_pu  "USB Low Speed mode - Pull up"
usb_fs  "USB Low Speed mode"
usb_fs_pd  "USB Full Speed mode - Pull Down"
usb_fs_pu2  "USB Full Speed mode - Pull up 2"
usb_fs_pu  "USB Full Speed mode - Pull up"
[Model Selector] ioreset_ft_v33
ioreset_1v2_pu  "RESET 1.2V range with PU"
ioreset_1v2  "RESET 1.2V range"
ioreset_1v8_pu  "RESET 1.8V range with PU"
ioreset_1v8  "RESET 1.8V range"
ioreset_3v3_pu  "RESET 3.3V range with PU"
ioreset_3v3  "RESET 3.3V range"
| Models and submodels in the file (66): usb_bmc_emit_pdccpd (I/O), usb_bmc_emit_pdcc3a0 (I/O), usb_bmc_emit_pdcc1a5 (I/O), usb_bmc_emit_pdccusb (I/O), usb_bmc_emit (I/O), io2_pdcc_ft_3v3_lowspeed (I/O), io2_pdcc_ft_3v3_mediumspeed (I/O), io2_pdcc_ft_3v3_lowspeed_pu (I/O), io2_pdcc_ft_3v3_mediumspeed_pu (I/O), io2_pdcc_ft_3v3_lowspeed_pd (I/O), io2_pdcc_ft_3v3_mediumspeed_pd (I/O), io2_pdcc_ft_1v8_lowspeed (I/O), io2_pdcc_ft_1v8_mediumspeed (I/O), io2_pdcc_ft_1v8_lowspeed_pu (I/O), io2_pdcc_ft_1v8_mediumspeed_pu (I/O), io2_pdcc_ft_1v8_lowspeed_pd (I/O), io2_pdcc_ft_1v8_mediumspeed_pd (I/O), io2_pdcc_ft_1v2_lowspeed (I/O), io2_pdcc_ft_1v2_mediumspeed (I/O), io2_pdcc_ft_1v2_lowspeed_pu (I/O), io2_pdcc_ft_1v2_mediumspeed_pu (I/O), io2_pdcc_ft_1v2_lowspeed_pd (I/O), io2_pdcc_ft_1v2_mediumspeed_pd (I/O), iols8p_sudq_ft_pd_lv (I/O), iols8p_sudq_ft_pu_lv (I/O), iols8p_sudq_ft_lv (I/O), iols8p_sudq_ft_pd (I/O), iols8p_sudq_ft_pu (I/O), iols8p_sudq_ft (I/O), iofs8p_sudq_ft_pd_lv (I/O), iofs8p_sudq_ft_pu_lv (I/O), iofs8p_sudq_ft_lv (I/O), iofs8p_sudq_ft_pd (I/O), iofs8p_sudq_ft_pu (I/O), iofs8p_sudq_ft (I/O), ioms8p_sudq_ft_pd_lv (I/O), ioms8p_sudq_ft_pu_lv (I/O), ioms8p_sudq_ft_lv (I/O), ioms8p_sudq_ft_pd (I/O), ioms8p_sudq_ft_pu (I/O), ioms8p_sudq_ft (I/O), iohs8p_sudq_ft_pd_lv (I/O), iohs8p_sudq_ft_pu_lv (I/O), iohs8p_sudq_ft_lv (I/O), iohs8p_sudq_ft_pd (I/O), iohs8p_sudq_ft_pu (I/O), iohs8p_sudq_ft (I/O), io8prog_1v8_i2c_pd (I/O_open_drain), io8prog_1v8_i2c_pu (I/O_open_drain), io8prog_1v8_i2c (I/O_open_drain), io8prog_3v3_i2c_pd (I/O_open_drain), io8prog_3v3_i2c_pu (I/O_open_drain), io8prog_3v3_i2c (I/O_open_drain), usb_ls_pd (I/O), usb_ls_pu2 (I/O), usb_ls_pu (I/O), usb_fs (I/O), usb_fs_pd (I/O), usb_fs_pu2 (I/O), usb_fs_pu (I/O), ioreset_1v2_pu (I/O_open_drain), ioreset_1v2 (I/O_open_drain), ioreset_1v8_pu (I/O_open_drain), ioreset_1v8 (I/O_open_drain), ioreset_3v3_pu (I/O_open_drain), ioreset_3v3 (I/O_open_drain)
