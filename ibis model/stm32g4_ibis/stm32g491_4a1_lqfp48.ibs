| IBIS file stm32g491_4a1_lqfp48.ibs
[IBIS ver] 4.2
[File name] stm32g491_4a1_lqfp48.ibs
[File Rev] 1.1
[Date] 29-07-2024
[Source] Data Created at STMicroelectronics
[Notes]  File originated from ELDO simulations.
[Disclaimer]  This information is for modeling purpose only and is
   not guaranteed. The information is subject to change without
   notice.
[Copyright] Copyright 2024 STMicroelectronics Inc.
|   Component stm32g491_4a1_lqfp48
[Component] stm32g491_4a1_lqfp48
[Manufacturer] STMicroelectronics
[Package]
| variable   typ   min   max
R_pkg  0  NA  NA
L_pkg  0  NA  NA
C_pkg  0  NA  NA
[Pin]   signal_name   model_name
1  VBAT  power
2  PC13  io8_ft_v33
3  PC14-OSC32_IN  io8_ft_v33
4  PC15-OSC32_OUT  io8_ft
5  PF0-OSC_IN  io8_ft_i2c
6  PF1-OSC_OUT  io8_ft
7  PG10-NRST  ioreset_ft_v33
8  PA0  io8_ft_v33
9  PA1  io8_ft
10  PA2  io8_ft_v33
11  PA3  io8_ft
12  PA4  io8_ft
13  PA5  io8_ft
14  PA6  io8_ft
15  PA7  io8_ft
16  PB0  io8_ft
17  PB1  io8_ft
18  PB2  io8_ft
19  VSSA  nc
20  VREFP  nc
21  VDDA  nc
22  PB10  io8_ft
23  VSS  gnd
24  VDD  power
25  PB11  io8_ft
26  PB12  io8_ft
27  PB13  io8_ft
28  PB14  io8_ft
29  PB15  io8_ft
30  PA8  io8_ft_i2c
31  PA9  io8_ft_i2c
32  PA10  io8_ft
33  PA11  io8usb_ft_phy
34  PA12  io8usb_ft_phy
35  VSS  gnd
36  VDD  power
37  PA13  io8_ft_i2c
38  PA14  io8_ft_i2c
39  PA15  io8_ft_i2c
40  PB3  io8_ft
41  PB4  nc
42  PB5  io8_ft_i2c
43  PB6  nc
44  PB7  io8_ft_i2c
45  PB8-BOOT0  io8_ft_i2c
46  PB9  io8_ft_i2c
47  VSS  gnd
48  VDD  power
[Package Model]   479-lqfp-7x7-48-240715
[Pin Mapping]   pulldown_ref   pullup_ref   | Comment
1  nc  vsw
2  gndio  vddio  | Depending on IO usage
| 2  gndio  vsw  | Depending on IO usage
3  gndio  vddio  | Depending on IO usage
| 3  gndio  vsw  | Depending on IO usage
4  gndio  vddio  | Depending on IO usage
| 4  gndio  vsw  | Depending on IO usage
5  gndio  vddio
6  gndio  vddio
7  gndio  vddio
8  gndio  vddio
9  gndio  vddio
10  gndio  vddio
11  gndio  vddio
12  gndio  vddio
13  gndio  vddio
14  gndio  vddio
15  gndio  vddio
16  gndio  vddio
17  gndio  vddio
18  gndio  vddio
19  nc  nc
20  nc  nc
21  nc  nc
22  gndio  vddio
23  gndio  nc
24  nc  vddio
25  gndio  vddio
26  gndio  vddio
27  gndio  vddio
28  gndio  vddio
29  gndio  vddio
30  gndio  vddio
31  gndio  vddio
32  gndio  vddio
33  gndio  vddio
34  gndio  vddio
35  gndio  nc
36  nc  vddio
37  gndio  vddio
38  gndio  vddio
39  gndio  vddio
40  gndio  vddio
41  nc  nc
42  gndio  vddio
43  nc  nc
44  gndio  vddio
45  gndio  vddio
46  gndio  vddio
47  gndio  nc
48  nc  vddio
|[Diff Pin]  inv_pin  vdiff  tdelay_typ  tdelay_min  tdelay_max
|34  33  NA  NA  NA  NA
[Model Selector] io8_ft
io8_ft_ls_1v2   "GPIO - 5V tolerant - 1.2V range - Low speed"
io8_ft_ms_1v2   "GPIO - 5V tolerant - 1.2V range - Med speed"
io8_ft_fs_1v2   "GPIO - 5V tolerant - 1.2V range - Fast speed"
io8_ft_hs_1v2   "GPIO - 5V tolerant - 1.2V range - High speed"
io8_ft_ls_1v8   "GPIO - 5V tolerant - 1.8V range - Low speed"
io8_ft_ms_1v8   "GPIO - 5V tolerant - 1.8V range - Med speed"
io8_ft_fs_1v8   "GPIO - 5V tolerant - 1.8V range - Fast speed"
io8_ft_hs_1v8   "GPIO - 5V tolerant - 1.8V range - High speed"
io8_ft_ls_3v3   "GPIO - 5V tolerant - 3.3V range - Low speed"
io8_ft_ms_3v3   "GPIO - 5V tolerant - 3.3V range - Med speed"
io8_ft_fs_3v3   "GPIO - 5V tolerant - 3.3V range - Fast speed"
io8_ft_hs_3v3   "GPIO - 5V tolerant - 3.3V range - High speed"
[Model Selector] io8_ft_i2c
io8_ft_ls_1v2   "GPIO - 5V tolerant - 1.2V range - Low speed"
io8_ft_ms_1v2   "GPIO - 5V tolerant - 1.2V range - Med speed"
io8_ft_fs_1v2   "GPIO - 5V tolerant - 1.2V range - Fast speed"
io8_ft_hs_1v2   "GPIO - 5V tolerant - 1.2V range - High speed"
io8_ft_ls_1v8   "GPIO - 5V tolerant - 1.8V range - Low speed"
io8_ft_ms_1v8   "GPIO - 5V tolerant - 1.8V range - Med speed"
io8_ft_fs_1v8   "GPIO - 5V tolerant - 1.8V range - Fast speed"
io8_ft_hs_1v8   "GPIO - 5V tolerant - 1.8V range - High speed"
io8_ft_ls_3v3   "GPIO - 5V tolerant - 3.3V range - Low speed"
io8_ft_ms_3v3   "GPIO - 5V tolerant - 3.3V range - Med speed"
io8_ft_fs_3v3   "GPIO - 5V tolerant - 3.3V range - Fast speed"
io8_ft_hs_3v3   "GPIO - 5V tolerant - 3.3V range - High speed"
io8_ft_i2c_ls_1v2   "GPIO I2C open-drain - 5V tolerant - 1.2V range - Low speed"
io8_ft_i2c_ms_1v2   "GPIO I2C open-drain - 5V tolerant - 1.2V range - Med speed"
io8_ft_i2c_fs_1v2   "GPIO I2C open-drain - 5V tolerant - 1.2V range - Fast speed"
io8_ft_i2c_hs_1v2   "GPIO I2C open-drain - 5V tolerant - 1.2V range - High speed"
io8_ft_i2c_ls_1v8   "GPIO I2C open-drain - 5V tolerant - 1.8V range - Low speed"
io8_ft_i2c_ms_1v8   "GPIO I2C open-drain - 5V tolerant - 1.8V range - Med speed"
io8_ft_i2c_fs_1v8   "GPIO I2C open-drain - 5V tolerant - 1.8V range - Fast speed"
io8_ft_i2c_hs_1v8   "GPIO I2C open-drain - 5V tolerant - 1.8V range - High speed"
io8_ft_i2c_ls_3v3   "GPIO I2C open-drain - 5V tolerant - 3.3V range - Low speed"
io8_ft_i2c_ms_3v3   "GPIO I2C open-drain - 5V tolerant - 3.3V range - Med speed"
io8_ft_i2c_fs_3v3   "GPIO I2C open-drain - 5V tolerant - 3.3V range - Fast speed"
io8_ft_i2c_hs_3v3   "GPIO I2C open-drain - 5V tolerant - 3.3V range - High speed"
io8_ft_i2c_fmp_3v3   "GPIO I2C open-drain fm+ - 5V tolerant - 3.3V range"
[Model Selector] io8_ft_v33
io8_ft_v33_ls_1v2   "GPIO_V33 - 5V tolerant - 1.2V range - Low speed"
io8_ft_v33_ms_1v2   "GPIO_V33 - 5V tolerant - 1.2V range - Med speed"
io8_ft_v33_fs_1v2   "GPIO_V33 - 5V tolerant - 1.2V range - Fast speed"
io8_ft_v33_hs_1v2   "GPIO_V33 - 5V tolerant - 1.2V range - High speed"
io8_ft_v33_ls_1v8   "GPIO_V33 - 5V tolerant - 1.8V range - Low speed"
io8_ft_v33_ms_1v8   "GPIO_V33 - 5V tolerant - 1.8V range - Med speed"
io8_ft_v33_fs_1v8   "GPIO_V33 - 5V tolerant - 1.8V range - Fast speed"
io8_ft_v33_hs_1v8   "GPIO_V33 - 5V tolerant - 1.8V range - High speed"
io8_ft_v33_ls_3v3   "GPIO_V33 - 5V tolerant - 3.3V range - Low speed"
io8_ft_v33_ms_3v3   "GPIO_V33 - 5V tolerant - 3.3V range - Med speed"
io8_ft_v33_fs_3v3   "GPIO_V33 - 5V tolerant - 3.3V range - Fast speed"
io8_ft_v33_hs_3v3   "GPIO_V33 - 5V tolerant - 3.3V range - High speed"
[Model Selector] io8usb_ft_phy
io8_ft_ls_1v2   "GPIO - 5V tolerant - 1.2V range - Low speed"
io8_ft_ms_1v2   "GPIO - 5V tolerant - 1.2V range - Med speed"
io8_ft_fs_1v2   "GPIO - 5V tolerant - 1.2V range - Fast speed"
io8_ft_hs_1v2   "GPIO - 5V tolerant - 1.2V range - High speed"
io8_ft_ls_1v8   "GPIO - 5V tolerant - 1.8V range - Low speed"
io8_ft_ms_1v8   "GPIO - 5V tolerant - 1.8V range - Med speed"
io8_ft_fs_1v8   "GPIO - 5V tolerant - 1.8V range - Fast speed"
io8_ft_hs_1v8   "GPIO - 5V tolerant - 1.8V range - High speed"
io8_ft_ls_3v3   "GPIO - 5V tolerant - 3.3V range - Low speed"
io8_ft_ms_3v3   "GPIO - 5V tolerant - 3.3V range - Med speed"
io8_ft_fs_3v3   "GPIO - 5V tolerant - 3.3V range - Fast speed"
io8_ft_hs_3v3   "GPIO - 5V tolerant - 3.3V range - High speed"
io8usb_ft_phy_hs_3v3   "USB full speed"
io8usb_ft_phy_ls_3v3   "USB low speed"
[Model Selector] ioreset_ft_v33
ioreset_ft_v33_1v2   "Reset PAD. 5V tolerant. 1.2V range"
ioreset_ft_v33_1v8   "Reset PAD. 5V tolerant. 1.8V range"
ioreset_ft_v33_3v3   "Reset PAD. 5V tolerant. 3.3V range"
[Define Package Model]  479-lqfp-7x7-48-240715
[Manufacturer]  Unknown
[OEM]  Unknown
[Description]  None
[Number Of Pins]  46
[Pin Numbers]
| Pin Num   Terminal Name
8 | PA0
9 | PA1
10 | PA2
11 | PA3
12 | PA4
13 | PA5
14 | PA6
15 | PA7
30 | PA8
31 | PA9
32 | PA10
33 | PA11
34 | PA12
37 | PA13
38 | PA14
39 | PA15
16 | PB0
17 | PB1
18 | PB2
40 | PB3
41 | PB4
42 | PB5
43 | PB6
44 | PB7
45 | PB8-BOOT0
46 | PB9
22 | PB10
25 | PB11
26 | PB12
27 | PB13
28 | PB14
29 | PB15
2 | PC13
3 | PC14-OSC32_IN
4 | PC15-OSC32_OUT
5 | PF0-OSC_IN
6 | PF1-OSC_OUT
7 | PG10-NRST
1 | VBAT
24 | VDD
36 | VDD
48 | VDD
21 | VDDA
20 | VREFP
23 | VSS
19 | VSSA
|[Merged Pins]  23
|35  |  VSS
|47  |  VSS
[Model Data]
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[End Model Data]
[End Package Model]
|End [Component]
| Models and submodels in the file (42): io8_ft_fs_1v2 (I/O), io8_ft_fs_1v8 (I/O), io8_ft_fs_3v3 (I/O), io8_ft_hs_1v2 (I/O), io8_ft_hs_1v8 (I/O), io8_ft_hs_3v3 (I/O), io8_ft_i2c_fmp_3v3 (I/O_open_drain), io8_ft_i2c_fs_1v2 (I/O_open_drain), io8_ft_i2c_fs_1v8 (I/O_open_drain), io8_ft_i2c_fs_3v3 (I/O_open_drain), io8_ft_i2c_hs_1v2 (I/O_open_drain), io8_ft_i2c_hs_1v8 (I/O_open_drain), io8_ft_i2c_hs_3v3 (I/O_open_drain), io8_ft_i2c_ls_1v2 (I/O_open_drain), io8_ft_i2c_ls_1v8 (I/O_open_drain), io8_ft_i2c_ls_3v3 (I/O_open_drain), io8_ft_i2c_ms_1v2 (I/O_open_drain), io8_ft_i2c_ms_1v8 (I/O_open_drain), io8_ft_i2c_ms_3v3 (I/O_open_drain), io8_ft_ls_1v2 (I/O), io8_ft_ls_1v8 (I/O), io8_ft_ls_3v3 (I/O), io8_ft_ms_1v2 (I/O), io8_ft_ms_1v8 (I/O), io8_ft_ms_3v3 (I/O), io8_ft_v33_fs_1v2 (I/O), io8_ft_v33_fs_1v8 (I/O), io8_ft_v33_fs_3v3 (I/O), io8_ft_v33_hs_1v2 (I/O), io8_ft_v33_hs_1v8 (I/O), io8_ft_v33_hs_3v3 (I/O), io8_ft_v33_ls_1v2 (I/O), io8_ft_v33_ls_1v8 (I/O), io8_ft_v33_ls_3v3 (I/O), io8_ft_v33_ms_1v2 (I/O), io8_ft_v33_ms_1v8 (I/O), io8_ft_v33_ms_3v3 (I/O), io8usb_ft_phy_hs_3v3 (I/O), io8usb_ft_phy_ls_3v3 (I/O), ioreset_ft_v33_1v2 (I/O_open_drain), ioreset_ft_v33_1v8 (I/O_open_drain), ioreset_ft_v33_3v3 (I/O_open_drain)
