| IBIS file stm32g471_473_474_483_484_tfbga100.ibs
[IBIS ver]   4.2
[File name]  stm32g471_473_474_483_484_tfbga100.ibs
[File Rev]   1.0
[Date]   08-07-2019
[Source]   Data Created at STMicroelectronics
[Notes]   File originated from ELDO simulations.
[Disclaimer] This information is for modeling purpose only and is
   not guaranted. The information is subject to change without
   notice.
[Copyright]  Copyright 2019 STMicroelectronics Inc.
|   Component stm32g471_473_474_483_484_tfbga100
[Component] stm32g471_473_474_483_484_tfbga100
[Manufacturer] STMicroelectronics
[Package]
| variable   typ   min   max
R_pkg  0  NA  NA
L_pkg  0  NA  NA
C_pkg  0  NA  NA
[Pin]   signal_name   model_name
A1  PE4  io8prog2m25m50m120m_sudq_ft
A2  PB9  io8prog2m25m50m120m_sudq_i2c_ft
A3  PB8-BOOT0  io8prog2m25m50m120m_sudq_i2c_ft
A4  PB6  io6usb_bmc_pd_cc_ft
A5  PB3  io8prog2m25m50m120m_sudq_ft
A6  PD6  io8prog2m25m50m120m_sudq_ft
A7  PD5  io8prog2m25m50m120m_sudq_ft
A8  PD4  io8prog2m25m50m120m_sudq_ft
A9  PD1  io8prog2m25m50m120m_sudq_ft
A10  PC12  io8prog2m25m50m120m_sudq_ft
B1  PE5  io8prog2m25m50m120m_sudq_ft
B2  PE3  io8prog2m25m50m120m_sudq_ft
B3  PE1  io8prog2m25m50m120m_sudq_ft
B4  PB7  io8prog2m25m50m120m_sudq_i2c_ft
B5  PB5  io8prog2m25m50m120m_sudq_i2c_ft
B6  PD7  io8prog2m25m50m120m_sudq_ft
B7  PD2  io8prog2m25m50m120m_sudq_ft
B8  PD0  io8prog2m25m50m120m_sudq_ft
B9  PA15  io8prog2m25m50m120m_sudq_i2c_ft
B10  PA14  io8prog2m25m50m120m_sudq_i2c_ft
C1  PC14-OSC32_IN  io8prog2m25m50m120m_sudq_ft
C2  PE6   io8prog2m25m50m120m_sudq_ft
C3  PE2  io8prog2m25m50m120m_sudq_ft
C4  PE0  io8prog2m25m50m120m_sudq_ft
C5  PB4  io6usb_bmc_pd_cc_ft
C6  PD3  io8prog2m25m50m120m_sudq_ft
C7  PC11  io8prog2m25m50m120m_sudq_i2c_ft
C8  PC10  io8prog2m25m50m120m_sudq_ft
C9  PA12  io8usblsfs_otg2
C10  PA11  io8usblsfs_otg2
D1  PC15-OSC32_OUT  io8prog2m25m50m120m_sudq_ft
D2  VSS  gnd
D3  VBAT  power
D4  PC13  io8prog2m25m50m120m_sudq_ft
D5  VDD  power
D6  VSS  gnd
D7  VDD  power
D8  PA13  io8prog2m25m50m120m_sudq_i2c_ft
D9  PA10  io8prog2m25m50m120m_sudq_i2c_ft
D10  PA9  io8prog2m25m50m120m_sudq_i2c_ft
E1  PF0-OSC_IN  io8prog2m25m50m120m_sudq_i2c_ft
E2  PF1-OSC_OUT  io8prog2m25m50m120m_sudq_ft
E3  PF9  io8prog2m25m50m120m_sudq_ft
E4  PF10  io8prog2m25m50m120m_sudq_ft
E5  VSS  gnd
E6  VSS  gnd
E7  VSS  gnd
E8  PC8  io8prog2m25m50m120m_sudq_i2c_ft
E9  PC9  io8prog2m25m50m120m_sudq_i2c_ft
E10  PA8  io8prog2m25m50m120m_sudq_ft
F1  PC2  io8prog2m25m50m120m_sudq_ft
F2  PC0  io8prog2m25m50m120m_sudq_ft
F3  PG10-NRST  ioreset_ft_v33
F4  PC1  io8prog2m25m50m120m_sudq_ft
F5  VDD  power
F6  VSS  gnd
F7  VDD  power
F8  PD14  io8prog2m25m50m120m_sudq_ft
F9  PC6  io8prog2m25m50m120m_sudq_i2c_ft
F10  PC7  io8prog2m25m50m120m_sudq_i2c_ft
G1  PC3  io8prog2m25m50m120m_sudq_ft
G2  PA1  io8prog2m25m50m120m_sudq_ft
G3  PF2  io8prog2m25m50m120m_sudq_ft
G4  PA0  io8prog2m25m50m120m_sudq_ft
G5  PE7  io8prog2m25m50m120m_sudq_ft
G6  PE12  io8prog2m25m50m120m_sudq_ft
G7  PD10  io8prog2m25m50m120m_sudq_ft
G8  PD9  io8prog2m25m50m120m_sudq_ft
G9  PD13  io8prog2m25m50m120m_sudq_ft
G10  PD15  io8prog2m25m50m120m_sudq_ft
H1  PA2  io8prog2m25m50m120m_sudq_ft
H2  PA4  io8prog2m25m50m120m_sudq_ft
H3  PA3  io8prog2m25m50m120m_sudq_ft
H4  PB0  io8prog2m25m50m120m_sudq_ft
H5  PE8  io8prog2m25m50m120m_sudq_ft
H6  PE9  io8prog2m25m50m120m_sudq_ft
H7  PE15  io8prog2m25m50m120m_sudq_ft
H8  PB11  io8prog2m25m50m120m_sudq_ft
H9  PB14  io8prog2m25m50m120m_sudq_ft
H10  PD11  io8prog2m25m50m120m_sudq_ft
J1  PA5  io8prog2m25m50m120m_sudq_ft
J2  PA6  io8prog2m25m50m120m_sudq_ft
J3  PC5  io8prog2m25m50m120m_sudq_ft
J4  PB2  io8prog2m25m50m120m_sudq_ft
J5  VDDA  nc
J6  PE11  io8prog2m25m50m120m_sudq_ft
J7  PE14  io8prog2m25m50m120m_sudq_ft
J8  PB10  io8prog2m25m50m120m_sudq_ft
J9  PB13  io8prog2m25m50m120m_sudq_ft
J10  PD12  io8prog2m25m50m120m_sudq_ft
K1  PA7  io8prog2m25m50m120m_sudq_ft
K2  PC4  io8prog2m25m50m120m_sudq_i2c_ft
K3  PB1  io8prog2m25m50m120m_sudq_ft
K4  VSSA  nc
K5  VREF+  nc
K6  PE10  io8prog2m25m50m120m_sudq_ft
K7  PE13  io8prog2m25m50m120m_sudq_ft
K8  PB12  io8prog2m25m50m120m_sudq_ft
K9  PB15  io8prog2m25m50m120m_sudq_ft
K10  PD8  io8prog2m25m50m120m_sudq_ft
[Package Model]   stm32g471_473_474_483_484_tfbga_100
[Pin Mapping]   pulldown_ref   pullup_ref   | Comment
A1  gndio  vddio
A2  gndio  vddio
A3  gndio  vddio
A4  gndio  vddio
A5  gndio  vddio
A6  gndio  vddio
A7  gndio  vddio
A8  gndio  vddio
A9  gndio  vddio
A10  gndio  vddio
B1  gndio  vddio
B2  gndio  vddio
B3  gndio  vddio
B4  gndio  vddio
B5  gndio  vddio
B6  gndio  vddio
B7  gndio  vddio
B8  gndio  vddio
B9  gndio  vddio
B10  gndio  vddio
C1  gndio  vddio  | Depending on IO usage
| C1  gndio  vswitch  | Depending on IO usage
C2  gndio  vddio
C3  gndio  vddio
C4  gndio  vddio
C5  gndio  vddio
C6  gndio  vddio
C7  gndio  vddio
C8  gndio  vddio
C9  gndio  vddio
C10  gndio  vddio
D1  gndio  vddio  | Depending on IO usage
| D1  gndio  vswitch  | Depending on IO usage
D2  gndio  nc
D3  nc  vswitch
D4  gndio  vddio  | Depending on IO usage
| D4  gndio  vswitch  | Depending on IO usage
D5  nc  vddio
D6  gndio  nc
D7  nc  vddio
D8  gndio  vddio
D9  gndio  vddio
D10  gndio  vddio
E1  gndio  vddio
E2  gndio  vddio
E3  gndio  vddio
E4  gndio  vddio
E5  gndio  nc
E6  gndio  nc
E7  gndio  nc
E8  gndio  vddio
E9  gndio  vddio
E10  gndio  vddio
F1  gndio  vddio
F2  gndio  vddio
F3  gndio  vddio
F4  gndio  vddio
F5  nc  vddio
F6  gndio  nc
F7  nc  vddio
F8  gndio  vddio
F9  gndio  vddio
F10  gndio  vddio
G1  gndio  vddio
G2  gndio  vddio
G3  gndio  vddio
G4  gndio  vddio
G5  gndio  vddio
G6  gndio  vddio
G7  gndio  vddio
G8  gndio  vddio
G9  gndio  vddio
G10  gndio  vddio
H1  gndio  vddio
H2  gndio  vddio
H3  gndio  vddio
H4  gndio  vddio
H5  gndio  vddio
H6  gndio  vddio
H7  gndio  vddio
H8  gndio  vddio
H9  gndio  vddio
H10  gndio  vddio
J1  gndio  vddio
J2  gndio  vddio
J3  gndio  vddio
J4  gndio  vddio
J5  nc  nc
J6  gndio  vddio
J7  gndio  vddio
J8  gndio  vddio
J9  gndio  vddio
J10  gndio  vddio
K1  gndio  vddio
K2  gndio  vddio
K3  gndio  vddio
K4  nc  nc
K5  nc  nc
K6  gndio  vddio
K7  gndio  vddio
K8  gndio  vddio
K9  gndio  vddio
K10  gndio  vddio
[Model Selector] io6usb_bmc_pd_cc_ft
usb_bmc_emit_pdccpd  "BMC PD emitter  + PD"
usb_bmc_emit_pdcc3a0  "BMC PD emitter  + 3rd PU"
usb_bmc_emit_pdcc1a5  "BMC PD emitter  + 2nd PU"
usb_bmc_emit_pdccusb  "BMC PD emitter  + 1st PU"
usb_bmc_emit  "BMC PD emitter "
io2_pdcc_ft_3v3_lowspeed  "GPIO-3.3V range - low speed"
io2_pdcc_ft_3v3_mediumspeed  "GPIO-3.3V range - medium speed"
io2_pdcc_ft_3v3_lowspeed_pu  "GPIO-3.3V range - low speed - pull up"
io2_pdcc_ft_3v3_mediumspeed_pu  "GPIO-3.3V range - medium speed - pull up"
io2_pdcc_ft_3v3_lowspeed_pd  "GPIO-3.3V range - low speed - pull down"
io2_pdcc_ft_3v3_mediumspeed_pd  "GPIO-3.3V range - medium speed - pull down"
io2_pdcc_ft_1v8_lowspeed  "GPIO-1.8V range - low speed"
io2_pdcc_ft_1v8_mediumspeed  "GPIO-1.8V range - medium speed"
io2_pdcc_ft_1v8_lowspeed_pu  "GPIO-1.8V range - low speed - pull up"
io2_pdcc_ft_1v8_mediumspeed_pu  "GPIO-1.8V range - medium speed - pull up"
io2_pdcc_ft_1v8_lowspeed_pd  "GPIO-1.8V range - low speed - pull down"
io2_pdcc_ft_1v8_mediumspeed_pd  "GPIO-1.8V range - medium speed - pull down"
io2_pdcc_ft_1v2_lowspeed  "GPIO-1.2V range - low speed"
io2_pdcc_ft_1v2_mediumspeed  "GPIO-1.2V range - medium speed"
io2_pdcc_ft_1v2_lowspeed_pu  "GPIO-1.2V range - low speed - pull up"
io2_pdcc_ft_1v2_mediumspeed_pu  "GPIO-1.2V range - medium speed - pull up"
io2_pdcc_ft_1v2_lowspeed_pd  "GPIO-1.2V range - low speed - pull down"
io2_pdcc_ft_1v2_mediumspeed_pd  "GPIO-1.2V range - medium speed - pull down"
[Model Selector] io8prog2m25m50m120m_sudq_ft
iols8p_sudq_ft_pd_lv  "IO low speed, PD=40kOhm - 1P8V"
iols8p_sudq_ft_pu_lv  "IO low speed, PU=40kOhm - 1P8V"
iols8p_sudq_ft_lv  "IO low speed - 1P8V"
iols8p_sudq_ft_pd  "IO low speed, PD=40kOhm - 3P3V"
iols8p_sudq_ft_pu  "IO low speed, PU=40kOhm - 3P3V"
iols8p_sudq_ft  "IO low speed - 3P3V"
iofs8p_sudq_ft_pd_lv  "IO full speed, PD=40kOhm - 1P8V"
iofs8p_sudq_ft_pu_lv  "IO full speed, PU=40kOhm - 1P8V"
iofs8p_sudq_ft_lv  "IO full speed - 1P8V"
iofs8p_sudq_ft_pd  "IO full speed, PD=40kOhm - 3P3V"
iofs8p_sudq_ft_pu  "IO full speed, PU=40kOhm - 3P3V"
iofs8p_sudq_ft  "IO full speed - 3P3V"
ioms8p_sudq_ft_pd_lv  "IO medium speed, PD=40kOhm - 1P8V"
ioms8p_sudq_ft_pu_lv  "IO medium speed, PU=40kOhm - 1P8V"
ioms8p_sudq_ft_lv  "IO medium speed - 1P8V"
ioms8p_sudq_ft_pd  "IO medium speed, PD=40kOhm - 3P3V"
ioms8p_sudq_ft_pu  "IO medium speed, PU=40kOhm - 3P3V"
ioms8p_sudq_ft  "IO medium speed - 3P3V"
iohs8p_sudq_ft_pd_lv  "IO high speed, PD=40kOhm - 1P8V"
iohs8p_sudq_ft_pu_lv  "IO high speed, PU=40kOhm - 1P8V"
iohs8p_sudq_ft_lv  "IO high speed - 1P8V"
iohs8p_sudq_ft_pd  "IO high speed, PD=40kOhm - 3P3V"
iohs8p_sudq_ft_pu  "IO high speed, PU=40kOhm - 3P3V"
iohs8p_sudq_ft  "IO high speed - 3P3V"
[Model Selector] io8prog2m25m50m120m_sudq_i2c_ft
io8prog_1v8_i2c_pd  "5V Tol GPIO 1.8V range i2c functionality with pull down"
io8prog_1v8_i2c_pu  "5V Tol GPIO 1.8V range i2c functionality with pull up"
io8prog_1v8_i2c  "5V Tol GPIO 1.8V range i2c functionality"
io8prog_3v3_i2c_pd  "5V Tol GPIO 3.3V range i2c functionality with pull down"
io8prog_3v3_i2c_pu  "5V Tol GPIO 3.3V range i2c functionality with pull up"
io8prog_3v3_i2c  "5V Tol GPIO 3.3V range i2c functionality"
iols8p_sudq_ft_pd_lv  "IO low speed, PD=40kOhm - 1P8V"
iols8p_sudq_ft_pu_lv  "IO low speed, PU=40kOhm - 1P8V"
iols8p_sudq_ft_lv  "IO low speed - 1P8V"
iols8p_sudq_ft_pd  "IO low speed, PD=40kOhm - 3P3V"
iols8p_sudq_ft_pu  "IO low speed, PU=40kOhm - 3P3V"
iols8p_sudq_ft  "IO low speed - 3P3V"
iofs8p_sudq_ft_pd_lv  "IO full speed, PD=40kOhm - 1P8V"
iofs8p_sudq_ft_pu_lv  "IO full speed, PU=40kOhm - 1P8V"
iofs8p_sudq_ft_lv  "IO full speed - 1P8V"
iofs8p_sudq_ft_pd  "IO full speed, PD=40kOhm - 3P3V"
iofs8p_sudq_ft_pu  "IO full speed, PU=40kOhm - 3P3V"
iofs8p_sudq_ft  "IO full speed - 3P3V"
ioms8p_sudq_ft_pd_lv  "IO medium speed, PD=40kOhm - 1P8V"
ioms8p_sudq_ft_pu_lv  "IO medium speed, PU=40kOhm - 1P8V"
ioms8p_sudq_ft_lv  "IO medium speed - 1P8V"
ioms8p_sudq_ft_pd  "IO medium speed, PD=40kOhm - 3P3V"
ioms8p_sudq_ft_pu  "IO medium speed, PU=40kOhm - 3P3V"
ioms8p_sudq_ft  "IO medium speed - 3P3V"
iohs8p_sudq_ft_pd_lv  "IO high speed, PD=40kOhm - 1P8V"
iohs8p_sudq_ft_pu_lv  "IO high speed, PU=40kOhm - 1P8V"
iohs8p_sudq_ft_lv  "IO high speed - 1P8V"
iohs8p_sudq_ft_pd  "IO high speed, PD=40kOhm - 3P3V"
iohs8p_sudq_ft_pu  "IO high speed, PU=40kOhm - 3P3V"
iohs8p_sudq_ft  "IO high speed - 3P3V"
[Model Selector] io8usblsfs_otg2
usb_ls_pd  "USB Low Speed mode - Pull Down"
usb_ls_pu2  "USB Low Speed mode - Pull up 2"
usb_ls_pu  "USB Low Speed mode - Pull up"
usb_fs  "USB Low Speed mode"
usb_fs_pd  "USB Full Speed mode - Pull Down"
usb_fs_pu2  "USB Full Speed mode - Pull up 2"
usb_fs_pu  "USB Full Speed mode - Pull up"
[Model Selector] ioreset_ft_v33
ioreset_1v2_pu  "RESET 1.2V range with PU"
ioreset_1v2  "RESET 1.2V range"
ioreset_1v8_pu  "RESET 1.8V range with PU"
ioreset_1v8  "RESET 1.8V range"
ioreset_3v3_pu  "RESET 3.3V range with PU"
ioreset_3v3  "RESET 3.3V range"
[Define Package Model]  stm32g471_473_474_483_484_tfbga_100
[Manufacturer]  Unknown
[OEM]  Unknown
[Description]  None
[Number Of Pins]  92
[Pin Numbers]
| Pin Num   Terminal Name
G4 | PA0
G2 | PA1
H1 | PA2
H3 | PA3
H2 | PA4
J1 | PA5
J2 | PA6
K1 | PA7
E10 | PA8
D10 | PA9
D9 | PA10
C10 | PA11
C9 | PA12
D8 | PA13
B10 | PA14
B9 | PA15
H4 | PB0
K3 | PB1
J4 | PB2
A5 | PB3
C5 | PB4
B5 | PB5
A4 | PB6
B4 | PB7
A3 | PB8-BOOT0
A2 | PB9
J8 | PB10
H8 | PB11
K8 | PB12
J9 | PB13
H9 | PB14
K9 | PB15
F2 | PC0
F4 | PC1
F1 | PC2
G1 | PC3
K2 | PC4
J3 | PC5
F9 | PC6
F10 | PC7
E8 | PC8
E9 | PC9
C8 | PC10
C7 | PC11
A10 | PC12
D4 | PC13
C1 | PC14-OSC32_IN
D1 | PC15-OSC32_OUT
B8 | PD0
A9 | PD1
B7 | PD2
C6 | PD3
A8 | PD4
A7 | PD5
A6 | PD6
B6 | PD7
K10 | PD8
G8 | PD9
G7 | PD10
H10 | PD11
J10 | PD12
G9 | PD13
F8 | PD14
G10 | PD15
C4 | PE0
B3 | PE1
C3 | PE2
B2 | PE3
A1 | PE4
B1 | PE5
C2 | PE6
G5 | PE7
H5 | PE8
H6 | PE9
K6 | PE10
J6 | PE11
G6 | PE12
K7 | PE13
J7 | PE14
H7 | PE15
E1 | PF0-OSC_IN
E2 | PF1-OSC_OUT
G3 | PF2
E3 | PF9
E4 | PF10
F3 | PG10-NRST
D3 | VBAT
D5 | VDD
J5 | VDDA
K5 | VREF+
D2 | VSS
K4 | VSSA
[Model Data]
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[End Model Data]
[End Package Model]
| Models and submodels in the file (66): usb_bmc_emit_pdccpd (I/O), usb_bmc_emit_pdcc3a0 (I/O), usb_bmc_emit_pdcc1a5 (I/O), usb_bmc_emit_pdccusb (I/O), usb_bmc_emit (I/O), io2_pdcc_ft_3v3_lowspeed (I/O), io2_pdcc_ft_3v3_mediumspeed (I/O), io2_pdcc_ft_3v3_lowspeed_pu (I/O), io2_pdcc_ft_3v3_mediumspeed_pu (I/O), io2_pdcc_ft_3v3_lowspeed_pd (I/O), io2_pdcc_ft_3v3_mediumspeed_pd (I/O), io2_pdcc_ft_1v8_lowspeed (I/O), io2_pdcc_ft_1v8_mediumspeed (I/O), io2_pdcc_ft_1v8_lowspeed_pu (I/O), io2_pdcc_ft_1v8_mediumspeed_pu (I/O), io2_pdcc_ft_1v8_lowspeed_pd (I/O), io2_pdcc_ft_1v8_mediumspeed_pd (I/O), io2_pdcc_ft_1v2_lowspeed (I/O), io2_pdcc_ft_1v2_mediumspeed (I/O), io2_pdcc_ft_1v2_lowspeed_pu (I/O), io2_pdcc_ft_1v2_mediumspeed_pu (I/O), io2_pdcc_ft_1v2_lowspeed_pd (I/O), io2_pdcc_ft_1v2_mediumspeed_pd (I/O), iols8p_sudq_ft_pd_lv (I/O), iols8p_sudq_ft_pu_lv (I/O), iols8p_sudq_ft_lv (I/O), iols8p_sudq_ft_pd (I/O), iols8p_sudq_ft_pu (I/O), iols8p_sudq_ft (I/O), iofs8p_sudq_ft_pd_lv (I/O), iofs8p_sudq_ft_pu_lv (I/O), iofs8p_sudq_ft_lv (I/O), iofs8p_sudq_ft_pd (I/O), iofs8p_sudq_ft_pu (I/O), iofs8p_sudq_ft (I/O), ioms8p_sudq_ft_pd_lv (I/O), ioms8p_sudq_ft_pu_lv (I/O), ioms8p_sudq_ft_lv (I/O), ioms8p_sudq_ft_pd (I/O), ioms8p_sudq_ft_pu (I/O), ioms8p_sudq_ft (I/O), iohs8p_sudq_ft_pd_lv (I/O), iohs8p_sudq_ft_pu_lv (I/O), iohs8p_sudq_ft_lv (I/O), iohs8p_sudq_ft_pd (I/O), iohs8p_sudq_ft_pu (I/O), iohs8p_sudq_ft (I/O), io8prog_1v8_i2c_pd (I/O), io8prog_1v8_i2c_pu (I/O), io8prog_1v8_i2c (I/O), io8prog_3v3_i2c_pd (I/O), io8prog_3v3_i2c_pu (I/O), io8prog_3v3_i2c (I/O), usb_ls_pd (I/O), usb_ls_pu2 (I/O), usb_ls_pu (I/O), usb_fs (I/O), usb_fs_pd (I/O), usb_fs_pu2 (I/O), usb_fs_pu (I/O), ioreset_1v2_pu (I/O_open_drain), ioreset_1v2 (I/O_open_drain), ioreset_1v8_pu (I/O_open_drain), ioreset_1v8 (I/O_open_drain), ioreset_3v3_pu (I/O_open_drain), ioreset_3v3 (I/O_open_drain)
